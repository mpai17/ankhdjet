* macro_array_pc_64x32_test0 LVS schematic (auto-generated from gen_abstracts.py)
.subckt macro_array_pc_64x32_test0 WL_0 WL_1 WL_2 WL_3 WL_4 WL_5 WL_6 WL_7 WL_8 WL_9 WL_10 WL_11 WL_12 WL_13 WL_14 WL_15 WL_16 WL_17 WL_18 WL_19 WL_20 WL_21 WL_22 WL_23 WL_24 WL_25 WL_26 WL_27 WL_28 WL_29 WL_30 WL_31 WL_32 WL_33 WL_34 WL_35 WL_36 WL_37 WL_38 WL_39 WL_40 WL_41 WL_42 WL_43 WL_44 WL_45 WL_46 WL_47 WL_48 WL_49 WL_50 WL_51 WL_52 WL_53 WL_54 WL_55 WL_56 WL_57 WL_58 WL_59 WL_60 WL_61 WL_62 WL_63 BLP_0 BLN_0 BLP_1 BLN_1 BLP_2 BLN_2 BLP_3 BLN_3 BLP_4 BLN_4 BLP_5 BLN_5 BLP_6 BLN_6 BLP_7 BLN_7 BLP_8 BLN_8 BLP_9 BLN_9 BLP_10 BLN_10 BLP_11 BLN_11 BLP_12 BLN_12 BLP_13 BLN_13 BLP_14 BLN_14 BLP_15 BLN_15 BLP_16 BLN_16 BLP_17 BLN_17 BLP_18 BLN_18 BLP_19 BLN_19 BLP_20 BLN_20 BLP_21 BLN_21 BLP_22 BLN_22 BLP_23 BLN_23 BLP_24 BLN_24 BLP_25 BLN_25 BLP_26 BLN_26 BLP_27 BLN_27 BLP_28 BLN_28 BLP_29 BLN_29 BLP_30 BLN_30 BLP_31 BLN_31 PRE_N VPWR VGND
XB0_0 VGND WL_0 BLN_0 VGND sky130_fd_pr__nfet_01v8 w=0.42 l=0.17
XB0_1 VGND WL_0 BLP_1 VGND sky130_fd_pr__nfet_01v8 w=0.42 l=0.17
XB0_2 VGND WL_0 BLP_2 VGND sky130_fd_pr__nfet_01v8 w=0.42 l=0.17
XB0_3 VGND WL_0 nc_0_3 VGND sky130_fd_pr__nfet_01v8 w=0.42 l=0.17
XB0_4 VGND WL_0 BLN_4 VGND sky130_fd_pr__nfet_01v8 w=0.42 l=0.17
XB0_5 VGND WL_0 nc_0_5 VGND sky130_fd_pr__nfet_01v8 w=0.42 l=0.17
XB0_6 VGND WL_0 nc_0_6 VGND sky130_fd_pr__nfet_01v8 w=0.42 l=0.17
XB0_7 VGND WL_0 BLN_7 VGND sky130_fd_pr__nfet_01v8 w=0.42 l=0.17
XB0_8 VGND WL_0 BLN_8 VGND sky130_fd_pr__nfet_01v8 w=0.42 l=0.17
XB0_9 VGND WL_0 nc_0_9 VGND sky130_fd_pr__nfet_01v8 w=0.42 l=0.17
XB0_10 VGND WL_0 BLP_10 VGND sky130_fd_pr__nfet_01v8 w=0.42 l=0.17
XB0_11 VGND WL_0 BLN_11 VGND sky130_fd_pr__nfet_01v8 w=0.42 l=0.17
XB0_12 VGND WL_0 nc_0_12 VGND sky130_fd_pr__nfet_01v8 w=0.42 l=0.17
XB0_13 VGND WL_0 nc_0_13 VGND sky130_fd_pr__nfet_01v8 w=0.42 l=0.17
XB0_14 VGND WL_0 nc_0_14 VGND sky130_fd_pr__nfet_01v8 w=0.42 l=0.17
XB0_15 VGND WL_0 nc_0_15 VGND sky130_fd_pr__nfet_01v8 w=0.42 l=0.17
XB0_16 VGND WL_0 nc_0_16 VGND sky130_fd_pr__nfet_01v8 w=0.42 l=0.17
XB0_17 VGND WL_0 nc_0_17 VGND sky130_fd_pr__nfet_01v8 w=0.42 l=0.17
XB0_18 VGND WL_0 BLN_18 VGND sky130_fd_pr__nfet_01v8 w=0.42 l=0.17
XB0_19 VGND WL_0 nc_0_19 VGND sky130_fd_pr__nfet_01v8 w=0.42 l=0.17
XB0_20 VGND WL_0 nc_0_20 VGND sky130_fd_pr__nfet_01v8 w=0.42 l=0.17
XB0_21 VGND WL_0 BLN_21 VGND sky130_fd_pr__nfet_01v8 w=0.42 l=0.17
XB0_22 VGND WL_0 BLN_22 VGND sky130_fd_pr__nfet_01v8 w=0.42 l=0.17
XB0_23 VGND WL_0 nc_0_23 VGND sky130_fd_pr__nfet_01v8 w=0.42 l=0.17
XB0_24 VGND WL_0 nc_0_24 VGND sky130_fd_pr__nfet_01v8 w=0.42 l=0.17
XB0_25 VGND WL_0 nc_0_25 VGND sky130_fd_pr__nfet_01v8 w=0.42 l=0.17
XB0_26 VGND WL_0 BLP_26 VGND sky130_fd_pr__nfet_01v8 w=0.42 l=0.17
XB0_27 VGND WL_0 nc_0_27 VGND sky130_fd_pr__nfet_01v8 w=0.42 l=0.17
XB0_28 VGND WL_0 nc_0_28 VGND sky130_fd_pr__nfet_01v8 w=0.42 l=0.17
XB0_29 VGND WL_0 nc_0_29 VGND sky130_fd_pr__nfet_01v8 w=0.42 l=0.17
XB0_30 VGND WL_0 nc_0_30 VGND sky130_fd_pr__nfet_01v8 w=0.42 l=0.17
XB0_31 VGND WL_0 BLP_31 VGND sky130_fd_pr__nfet_01v8 w=0.42 l=0.17
XB1_0 VGND WL_1 BLP_0 VGND sky130_fd_pr__nfet_01v8 w=0.42 l=0.17
XB1_1 VGND WL_1 BLN_1 VGND sky130_fd_pr__nfet_01v8 w=0.42 l=0.17
XB1_2 VGND WL_1 BLP_2 VGND sky130_fd_pr__nfet_01v8 w=0.42 l=0.17
XB1_3 VGND WL_1 BLN_3 VGND sky130_fd_pr__nfet_01v8 w=0.42 l=0.17
XB1_4 VGND WL_1 BLN_4 VGND sky130_fd_pr__nfet_01v8 w=0.42 l=0.17
XB1_5 VGND WL_1 BLN_5 VGND sky130_fd_pr__nfet_01v8 w=0.42 l=0.17
XB1_6 VGND WL_1 nc_1_6 VGND sky130_fd_pr__nfet_01v8 w=0.42 l=0.17
XB1_7 VGND WL_1 nc_1_7 VGND sky130_fd_pr__nfet_01v8 w=0.42 l=0.17
XB1_8 VGND WL_1 nc_1_8 VGND sky130_fd_pr__nfet_01v8 w=0.42 l=0.17
XB1_9 VGND WL_1 nc_1_9 VGND sky130_fd_pr__nfet_01v8 w=0.42 l=0.17
XB1_10 VGND WL_1 BLN_10 VGND sky130_fd_pr__nfet_01v8 w=0.42 l=0.17
XB1_11 VGND WL_1 nc_1_11 VGND sky130_fd_pr__nfet_01v8 w=0.42 l=0.17
XB1_12 VGND WL_1 BLP_12 VGND sky130_fd_pr__nfet_01v8 w=0.42 l=0.17
XB1_13 VGND WL_1 nc_1_13 VGND sky130_fd_pr__nfet_01v8 w=0.42 l=0.17
XB1_14 VGND WL_1 BLN_14 VGND sky130_fd_pr__nfet_01v8 w=0.42 l=0.17
XB1_15 VGND WL_1 nc_1_15 VGND sky130_fd_pr__nfet_01v8 w=0.42 l=0.17
XB1_16 VGND WL_1 nc_1_16 VGND sky130_fd_pr__nfet_01v8 w=0.42 l=0.17
XB1_17 VGND WL_1 nc_1_17 VGND sky130_fd_pr__nfet_01v8 w=0.42 l=0.17
XB1_18 VGND WL_1 BLN_18 VGND sky130_fd_pr__nfet_01v8 w=0.42 l=0.17
XB1_19 VGND WL_1 nc_1_19 VGND sky130_fd_pr__nfet_01v8 w=0.42 l=0.17
XB1_20 VGND WL_1 BLP_20 VGND sky130_fd_pr__nfet_01v8 w=0.42 l=0.17
XB1_21 VGND WL_1 BLN_21 VGND sky130_fd_pr__nfet_01v8 w=0.42 l=0.17
XB1_22 VGND WL_1 nc_1_22 VGND sky130_fd_pr__nfet_01v8 w=0.42 l=0.17
XB1_23 VGND WL_1 nc_1_23 VGND sky130_fd_pr__nfet_01v8 w=0.42 l=0.17
XB1_24 VGND WL_1 nc_1_24 VGND sky130_fd_pr__nfet_01v8 w=0.42 l=0.17
XB1_25 VGND WL_1 nc_1_25 VGND sky130_fd_pr__nfet_01v8 w=0.42 l=0.17
XB1_26 VGND WL_1 BLP_26 VGND sky130_fd_pr__nfet_01v8 w=0.42 l=0.17
XB1_27 VGND WL_1 BLN_27 VGND sky130_fd_pr__nfet_01v8 w=0.42 l=0.17
XB1_28 VGND WL_1 BLP_28 VGND sky130_fd_pr__nfet_01v8 w=0.42 l=0.17
XB1_29 VGND WL_1 nc_1_29 VGND sky130_fd_pr__nfet_01v8 w=0.42 l=0.17
XB1_30 VGND WL_1 nc_1_30 VGND sky130_fd_pr__nfet_01v8 w=0.42 l=0.17
XB1_31 VGND WL_1 BLP_31 VGND sky130_fd_pr__nfet_01v8 w=0.42 l=0.17
XB2_0 VGND WL_2 BLN_0 VGND sky130_fd_pr__nfet_01v8 w=0.42 l=0.17
XB2_1 VGND WL_2 BLN_1 VGND sky130_fd_pr__nfet_01v8 w=0.42 l=0.17
XB2_2 VGND WL_2 BLP_2 VGND sky130_fd_pr__nfet_01v8 w=0.42 l=0.17
XB2_3 VGND WL_2 nc_2_3 VGND sky130_fd_pr__nfet_01v8 w=0.42 l=0.17
XB2_4 VGND WL_2 BLN_4 VGND sky130_fd_pr__nfet_01v8 w=0.42 l=0.17
XB2_5 VGND WL_2 BLP_5 VGND sky130_fd_pr__nfet_01v8 w=0.42 l=0.17
XB2_6 VGND WL_2 nc_2_6 VGND sky130_fd_pr__nfet_01v8 w=0.42 l=0.17
XB2_7 VGND WL_2 BLN_7 VGND sky130_fd_pr__nfet_01v8 w=0.42 l=0.17
XB2_8 VGND WL_2 BLN_8 VGND sky130_fd_pr__nfet_01v8 w=0.42 l=0.17
XB2_9 VGND WL_2 BLP_9 VGND sky130_fd_pr__nfet_01v8 w=0.42 l=0.17
XB2_10 VGND WL_2 BLP_10 VGND sky130_fd_pr__nfet_01v8 w=0.42 l=0.17
XB2_11 VGND WL_2 nc_2_11 VGND sky130_fd_pr__nfet_01v8 w=0.42 l=0.17
XB2_12 VGND WL_2 nc_2_12 VGND sky130_fd_pr__nfet_01v8 w=0.42 l=0.17
XB2_13 VGND WL_2 BLN_13 VGND sky130_fd_pr__nfet_01v8 w=0.42 l=0.17
XB2_14 VGND WL_2 nc_2_14 VGND sky130_fd_pr__nfet_01v8 w=0.42 l=0.17
XB2_15 VGND WL_2 BLP_15 VGND sky130_fd_pr__nfet_01v8 w=0.42 l=0.17
XB2_16 VGND WL_2 nc_2_16 VGND sky130_fd_pr__nfet_01v8 w=0.42 l=0.17
XB2_17 VGND WL_2 nc_2_17 VGND sky130_fd_pr__nfet_01v8 w=0.42 l=0.17
XB2_18 VGND WL_2 nc_2_18 VGND sky130_fd_pr__nfet_01v8 w=0.42 l=0.17
XB2_19 VGND WL_2 BLN_19 VGND sky130_fd_pr__nfet_01v8 w=0.42 l=0.17
XB2_20 VGND WL_2 nc_2_20 VGND sky130_fd_pr__nfet_01v8 w=0.42 l=0.17
XB2_21 VGND WL_2 BLP_21 VGND sky130_fd_pr__nfet_01v8 w=0.42 l=0.17
XB2_22 VGND WL_2 BLN_22 VGND sky130_fd_pr__nfet_01v8 w=0.42 l=0.17
XB2_23 VGND WL_2 BLN_23 VGND sky130_fd_pr__nfet_01v8 w=0.42 l=0.17
XB2_24 VGND WL_2 nc_2_24 VGND sky130_fd_pr__nfet_01v8 w=0.42 l=0.17
XB2_25 VGND WL_2 BLN_25 VGND sky130_fd_pr__nfet_01v8 w=0.42 l=0.17
XB2_26 VGND WL_2 BLP_26 VGND sky130_fd_pr__nfet_01v8 w=0.42 l=0.17
XB2_27 VGND WL_2 nc_2_27 VGND sky130_fd_pr__nfet_01v8 w=0.42 l=0.17
XB2_28 VGND WL_2 nc_2_28 VGND sky130_fd_pr__nfet_01v8 w=0.42 l=0.17
XB2_29 VGND WL_2 nc_2_29 VGND sky130_fd_pr__nfet_01v8 w=0.42 l=0.17
XB2_30 VGND WL_2 nc_2_30 VGND sky130_fd_pr__nfet_01v8 w=0.42 l=0.17
XB2_31 VGND WL_2 BLN_31 VGND sky130_fd_pr__nfet_01v8 w=0.42 l=0.17
XB3_0 VGND WL_3 nc_3_0 VGND sky130_fd_pr__nfet_01v8 w=0.42 l=0.17
XB3_1 VGND WL_3 BLN_1 VGND sky130_fd_pr__nfet_01v8 w=0.42 l=0.17
XB3_2 VGND WL_3 nc_3_2 VGND sky130_fd_pr__nfet_01v8 w=0.42 l=0.17
XB3_3 VGND WL_3 BLN_3 VGND sky130_fd_pr__nfet_01v8 w=0.42 l=0.17
XB3_4 VGND WL_3 nc_3_4 VGND sky130_fd_pr__nfet_01v8 w=0.42 l=0.17
XB3_5 VGND WL_3 BLP_5 VGND sky130_fd_pr__nfet_01v8 w=0.42 l=0.17
XB3_6 VGND WL_3 nc_3_6 VGND sky130_fd_pr__nfet_01v8 w=0.42 l=0.17
XB3_7 VGND WL_3 BLN_7 VGND sky130_fd_pr__nfet_01v8 w=0.42 l=0.17
XB3_8 VGND WL_3 nc_3_8 VGND sky130_fd_pr__nfet_01v8 w=0.42 l=0.17
XB3_9 VGND WL_3 nc_3_9 VGND sky130_fd_pr__nfet_01v8 w=0.42 l=0.17
XB3_10 VGND WL_3 BLP_10 VGND sky130_fd_pr__nfet_01v8 w=0.42 l=0.17
XB3_11 VGND WL_3 BLN_11 VGND sky130_fd_pr__nfet_01v8 w=0.42 l=0.17
XB3_12 VGND WL_3 nc_3_12 VGND sky130_fd_pr__nfet_01v8 w=0.42 l=0.17
XB3_13 VGND WL_3 nc_3_13 VGND sky130_fd_pr__nfet_01v8 w=0.42 l=0.17
XB3_14 VGND WL_3 BLP_14 VGND sky130_fd_pr__nfet_01v8 w=0.42 l=0.17
XB3_15 VGND WL_3 BLP_15 VGND sky130_fd_pr__nfet_01v8 w=0.42 l=0.17
XB3_16 VGND WL_3 nc_3_16 VGND sky130_fd_pr__nfet_01v8 w=0.42 l=0.17
XB3_17 VGND WL_3 nc_3_17 VGND sky130_fd_pr__nfet_01v8 w=0.42 l=0.17
XB3_18 VGND WL_3 nc_3_18 VGND sky130_fd_pr__nfet_01v8 w=0.42 l=0.17
XB3_19 VGND WL_3 BLN_19 VGND sky130_fd_pr__nfet_01v8 w=0.42 l=0.17
XB3_20 VGND WL_3 BLP_20 VGND sky130_fd_pr__nfet_01v8 w=0.42 l=0.17
XB3_21 VGND WL_3 nc_3_21 VGND sky130_fd_pr__nfet_01v8 w=0.42 l=0.17
XB3_22 VGND WL_3 nc_3_22 VGND sky130_fd_pr__nfet_01v8 w=0.42 l=0.17
XB3_23 VGND WL_3 nc_3_23 VGND sky130_fd_pr__nfet_01v8 w=0.42 l=0.17
XB3_24 VGND WL_3 nc_3_24 VGND sky130_fd_pr__nfet_01v8 w=0.42 l=0.17
XB3_25 VGND WL_3 nc_3_25 VGND sky130_fd_pr__nfet_01v8 w=0.42 l=0.17
XB3_26 VGND WL_3 BLN_26 VGND sky130_fd_pr__nfet_01v8 w=0.42 l=0.17
XB3_27 VGND WL_3 BLN_27 VGND sky130_fd_pr__nfet_01v8 w=0.42 l=0.17
XB3_28 VGND WL_3 BLN_28 VGND sky130_fd_pr__nfet_01v8 w=0.42 l=0.17
XB3_29 VGND WL_3 BLN_29 VGND sky130_fd_pr__nfet_01v8 w=0.42 l=0.17
XB3_30 VGND WL_3 BLN_30 VGND sky130_fd_pr__nfet_01v8 w=0.42 l=0.17
XB3_31 VGND WL_3 BLP_31 VGND sky130_fd_pr__nfet_01v8 w=0.42 l=0.17
XB4_0 VGND WL_4 BLN_0 VGND sky130_fd_pr__nfet_01v8 w=0.42 l=0.17
XB4_1 VGND WL_4 nc_4_1 VGND sky130_fd_pr__nfet_01v8 w=0.42 l=0.17
XB4_2 VGND WL_4 BLN_2 VGND sky130_fd_pr__nfet_01v8 w=0.42 l=0.17
XB4_3 VGND WL_4 BLN_3 VGND sky130_fd_pr__nfet_01v8 w=0.42 l=0.17
XB4_4 VGND WL_4 BLP_4 VGND sky130_fd_pr__nfet_01v8 w=0.42 l=0.17
XB4_5 VGND WL_4 BLN_5 VGND sky130_fd_pr__nfet_01v8 w=0.42 l=0.17
XB4_6 VGND WL_4 BLN_6 VGND sky130_fd_pr__nfet_01v8 w=0.42 l=0.17
XB4_7 VGND WL_4 BLN_7 VGND sky130_fd_pr__nfet_01v8 w=0.42 l=0.17
XB4_8 VGND WL_4 nc_4_8 VGND sky130_fd_pr__nfet_01v8 w=0.42 l=0.17
XB4_9 VGND WL_4 BLN_9 VGND sky130_fd_pr__nfet_01v8 w=0.42 l=0.17
XB4_10 VGND WL_4 nc_4_10 VGND sky130_fd_pr__nfet_01v8 w=0.42 l=0.17
XB4_11 VGND WL_4 nc_4_11 VGND sky130_fd_pr__nfet_01v8 w=0.42 l=0.17
XB4_12 VGND WL_4 BLN_12 VGND sky130_fd_pr__nfet_01v8 w=0.42 l=0.17
XB4_13 VGND WL_4 BLN_13 VGND sky130_fd_pr__nfet_01v8 w=0.42 l=0.17
XB4_14 VGND WL_4 BLN_14 VGND sky130_fd_pr__nfet_01v8 w=0.42 l=0.17
XB4_15 VGND WL_4 BLP_15 VGND sky130_fd_pr__nfet_01v8 w=0.42 l=0.17
XB4_16 VGND WL_4 BLN_16 VGND sky130_fd_pr__nfet_01v8 w=0.42 l=0.17
XB4_17 VGND WL_4 nc_4_17 VGND sky130_fd_pr__nfet_01v8 w=0.42 l=0.17
XB4_18 VGND WL_4 nc_4_18 VGND sky130_fd_pr__nfet_01v8 w=0.42 l=0.17
XB4_19 VGND WL_4 BLP_19 VGND sky130_fd_pr__nfet_01v8 w=0.42 l=0.17
XB4_20 VGND WL_4 BLN_20 VGND sky130_fd_pr__nfet_01v8 w=0.42 l=0.17
XB4_21 VGND WL_4 BLN_21 VGND sky130_fd_pr__nfet_01v8 w=0.42 l=0.17
XB4_22 VGND WL_4 BLP_22 VGND sky130_fd_pr__nfet_01v8 w=0.42 l=0.17
XB4_23 VGND WL_4 nc_4_23 VGND sky130_fd_pr__nfet_01v8 w=0.42 l=0.17
XB4_24 VGND WL_4 nc_4_24 VGND sky130_fd_pr__nfet_01v8 w=0.42 l=0.17
XB4_25 VGND WL_4 nc_4_25 VGND sky130_fd_pr__nfet_01v8 w=0.42 l=0.17
XB4_26 VGND WL_4 BLP_26 VGND sky130_fd_pr__nfet_01v8 w=0.42 l=0.17
XB4_27 VGND WL_4 nc_4_27 VGND sky130_fd_pr__nfet_01v8 w=0.42 l=0.17
XB4_28 VGND WL_4 BLP_28 VGND sky130_fd_pr__nfet_01v8 w=0.42 l=0.17
XB4_29 VGND WL_4 BLN_29 VGND sky130_fd_pr__nfet_01v8 w=0.42 l=0.17
XB4_30 VGND WL_4 nc_4_30 VGND sky130_fd_pr__nfet_01v8 w=0.42 l=0.17
XB4_31 VGND WL_4 BLP_31 VGND sky130_fd_pr__nfet_01v8 w=0.42 l=0.17
XB5_0 VGND WL_5 BLP_0 VGND sky130_fd_pr__nfet_01v8 w=0.42 l=0.17
XB5_1 VGND WL_5 nc_5_1 VGND sky130_fd_pr__nfet_01v8 w=0.42 l=0.17
XB5_2 VGND WL_5 nc_5_2 VGND sky130_fd_pr__nfet_01v8 w=0.42 l=0.17
XB5_3 VGND WL_5 BLP_3 VGND sky130_fd_pr__nfet_01v8 w=0.42 l=0.17
XB5_4 VGND WL_5 BLP_4 VGND sky130_fd_pr__nfet_01v8 w=0.42 l=0.17
XB5_5 VGND WL_5 BLN_5 VGND sky130_fd_pr__nfet_01v8 w=0.42 l=0.17
XB5_6 VGND WL_5 nc_5_6 VGND sky130_fd_pr__nfet_01v8 w=0.42 l=0.17
XB5_7 VGND WL_5 nc_5_7 VGND sky130_fd_pr__nfet_01v8 w=0.42 l=0.17
XB5_8 VGND WL_5 nc_5_8 VGND sky130_fd_pr__nfet_01v8 w=0.42 l=0.17
XB5_9 VGND WL_5 BLN_9 VGND sky130_fd_pr__nfet_01v8 w=0.42 l=0.17
XB5_10 VGND WL_5 BLP_10 VGND sky130_fd_pr__nfet_01v8 w=0.42 l=0.17
XB5_11 VGND WL_5 nc_5_11 VGND sky130_fd_pr__nfet_01v8 w=0.42 l=0.17
XB5_12 VGND WL_5 BLP_12 VGND sky130_fd_pr__nfet_01v8 w=0.42 l=0.17
XB5_13 VGND WL_5 nc_5_13 VGND sky130_fd_pr__nfet_01v8 w=0.42 l=0.17
XB5_14 VGND WL_5 nc_5_14 VGND sky130_fd_pr__nfet_01v8 w=0.42 l=0.17
XB5_15 VGND WL_5 nc_5_15 VGND sky130_fd_pr__nfet_01v8 w=0.42 l=0.17
XB5_16 VGND WL_5 nc_5_16 VGND sky130_fd_pr__nfet_01v8 w=0.42 l=0.17
XB5_17 VGND WL_5 BLP_17 VGND sky130_fd_pr__nfet_01v8 w=0.42 l=0.17
XB5_18 VGND WL_5 nc_5_18 VGND sky130_fd_pr__nfet_01v8 w=0.42 l=0.17
XB5_19 VGND WL_5 nc_5_19 VGND sky130_fd_pr__nfet_01v8 w=0.42 l=0.17
XB5_20 VGND WL_5 BLN_20 VGND sky130_fd_pr__nfet_01v8 w=0.42 l=0.17
XB5_21 VGND WL_5 BLN_21 VGND sky130_fd_pr__nfet_01v8 w=0.42 l=0.17
XB5_22 VGND WL_5 nc_5_22 VGND sky130_fd_pr__nfet_01v8 w=0.42 l=0.17
XB5_23 VGND WL_5 nc_5_23 VGND sky130_fd_pr__nfet_01v8 w=0.42 l=0.17
XB5_24 VGND WL_5 BLN_24 VGND sky130_fd_pr__nfet_01v8 w=0.42 l=0.17
XB5_25 VGND WL_5 nc_5_25 VGND sky130_fd_pr__nfet_01v8 w=0.42 l=0.17
XB5_26 VGND WL_5 nc_5_26 VGND sky130_fd_pr__nfet_01v8 w=0.42 l=0.17
XB5_27 VGND WL_5 BLP_27 VGND sky130_fd_pr__nfet_01v8 w=0.42 l=0.17
XB5_28 VGND WL_5 nc_5_28 VGND sky130_fd_pr__nfet_01v8 w=0.42 l=0.17
XB5_29 VGND WL_5 nc_5_29 VGND sky130_fd_pr__nfet_01v8 w=0.42 l=0.17
XB5_30 VGND WL_5 nc_5_30 VGND sky130_fd_pr__nfet_01v8 w=0.42 l=0.17
XB5_31 VGND WL_5 BLP_31 VGND sky130_fd_pr__nfet_01v8 w=0.42 l=0.17
XB6_0 VGND WL_6 nc_6_0 VGND sky130_fd_pr__nfet_01v8 w=0.42 l=0.17
XB6_1 VGND WL_6 nc_6_1 VGND sky130_fd_pr__nfet_01v8 w=0.42 l=0.17
XB6_2 VGND WL_6 nc_6_2 VGND sky130_fd_pr__nfet_01v8 w=0.42 l=0.17
XB6_3 VGND WL_6 BLP_3 VGND sky130_fd_pr__nfet_01v8 w=0.42 l=0.17
XB6_4 VGND WL_6 nc_6_4 VGND sky130_fd_pr__nfet_01v8 w=0.42 l=0.17
XB6_5 VGND WL_6 BLP_5 VGND sky130_fd_pr__nfet_01v8 w=0.42 l=0.17
XB6_6 VGND WL_6 nc_6_6 VGND sky130_fd_pr__nfet_01v8 w=0.42 l=0.17
XB6_7 VGND WL_6 BLN_7 VGND sky130_fd_pr__nfet_01v8 w=0.42 l=0.17
XB6_8 VGND WL_6 nc_6_8 VGND sky130_fd_pr__nfet_01v8 w=0.42 l=0.17
XB6_9 VGND WL_6 nc_6_9 VGND sky130_fd_pr__nfet_01v8 w=0.42 l=0.17
XB6_10 VGND WL_6 nc_6_10 VGND sky130_fd_pr__nfet_01v8 w=0.42 l=0.17
XB6_11 VGND WL_6 nc_6_11 VGND sky130_fd_pr__nfet_01v8 w=0.42 l=0.17
XB6_12 VGND WL_6 BLP_12 VGND sky130_fd_pr__nfet_01v8 w=0.42 l=0.17
XB6_13 VGND WL_6 BLN_13 VGND sky130_fd_pr__nfet_01v8 w=0.42 l=0.17
XB6_14 VGND WL_6 nc_6_14 VGND sky130_fd_pr__nfet_01v8 w=0.42 l=0.17
XB6_15 VGND WL_6 nc_6_15 VGND sky130_fd_pr__nfet_01v8 w=0.42 l=0.17
XB6_16 VGND WL_6 nc_6_16 VGND sky130_fd_pr__nfet_01v8 w=0.42 l=0.17
XB6_17 VGND WL_6 nc_6_17 VGND sky130_fd_pr__nfet_01v8 w=0.42 l=0.17
XB6_18 VGND WL_6 nc_6_18 VGND sky130_fd_pr__nfet_01v8 w=0.42 l=0.17
XB6_19 VGND WL_6 BLP_19 VGND sky130_fd_pr__nfet_01v8 w=0.42 l=0.17
XB6_20 VGND WL_6 BLN_20 VGND sky130_fd_pr__nfet_01v8 w=0.42 l=0.17
XB6_21 VGND WL_6 BLP_21 VGND sky130_fd_pr__nfet_01v8 w=0.42 l=0.17
XB6_22 VGND WL_6 nc_6_22 VGND sky130_fd_pr__nfet_01v8 w=0.42 l=0.17
XB6_23 VGND WL_6 nc_6_23 VGND sky130_fd_pr__nfet_01v8 w=0.42 l=0.17
XB6_24 VGND WL_6 nc_6_24 VGND sky130_fd_pr__nfet_01v8 w=0.42 l=0.17
XB6_25 VGND WL_6 nc_6_25 VGND sky130_fd_pr__nfet_01v8 w=0.42 l=0.17
XB6_26 VGND WL_6 BLN_26 VGND sky130_fd_pr__nfet_01v8 w=0.42 l=0.17
XB6_27 VGND WL_6 BLP_27 VGND sky130_fd_pr__nfet_01v8 w=0.42 l=0.17
XB6_28 VGND WL_6 BLN_28 VGND sky130_fd_pr__nfet_01v8 w=0.42 l=0.17
XB6_29 VGND WL_6 BLP_29 VGND sky130_fd_pr__nfet_01v8 w=0.42 l=0.17
XB6_30 VGND WL_6 BLP_30 VGND sky130_fd_pr__nfet_01v8 w=0.42 l=0.17
XB6_31 VGND WL_6 nc_6_31 VGND sky130_fd_pr__nfet_01v8 w=0.42 l=0.17
XB7_0 VGND WL_7 BLN_0 VGND sky130_fd_pr__nfet_01v8 w=0.42 l=0.17
XB7_1 VGND WL_7 nc_7_1 VGND sky130_fd_pr__nfet_01v8 w=0.42 l=0.17
XB7_2 VGND WL_7 nc_7_2 VGND sky130_fd_pr__nfet_01v8 w=0.42 l=0.17
XB7_3 VGND WL_7 BLN_3 VGND sky130_fd_pr__nfet_01v8 w=0.42 l=0.17
XB7_4 VGND WL_7 nc_7_4 VGND sky130_fd_pr__nfet_01v8 w=0.42 l=0.17
XB7_5 VGND WL_7 nc_7_5 VGND sky130_fd_pr__nfet_01v8 w=0.42 l=0.17
XB7_6 VGND WL_7 BLN_6 VGND sky130_fd_pr__nfet_01v8 w=0.42 l=0.17
XB7_7 VGND WL_7 nc_7_7 VGND sky130_fd_pr__nfet_01v8 w=0.42 l=0.17
XB7_8 VGND WL_7 nc_7_8 VGND sky130_fd_pr__nfet_01v8 w=0.42 l=0.17
XB7_9 VGND WL_7 nc_7_9 VGND sky130_fd_pr__nfet_01v8 w=0.42 l=0.17
XB7_10 VGND WL_7 BLN_10 VGND sky130_fd_pr__nfet_01v8 w=0.42 l=0.17
XB7_11 VGND WL_7 nc_7_11 VGND sky130_fd_pr__nfet_01v8 w=0.42 l=0.17
XB7_12 VGND WL_7 BLP_12 VGND sky130_fd_pr__nfet_01v8 w=0.42 l=0.17
XB7_13 VGND WL_7 BLP_13 VGND sky130_fd_pr__nfet_01v8 w=0.42 l=0.17
XB7_14 VGND WL_7 nc_7_14 VGND sky130_fd_pr__nfet_01v8 w=0.42 l=0.17
XB7_15 VGND WL_7 nc_7_15 VGND sky130_fd_pr__nfet_01v8 w=0.42 l=0.17
XB7_16 VGND WL_7 BLP_16 VGND sky130_fd_pr__nfet_01v8 w=0.42 l=0.17
XB7_17 VGND WL_7 nc_7_17 VGND sky130_fd_pr__nfet_01v8 w=0.42 l=0.17
XB7_18 VGND WL_7 BLP_18 VGND sky130_fd_pr__nfet_01v8 w=0.42 l=0.17
XB7_19 VGND WL_7 nc_7_19 VGND sky130_fd_pr__nfet_01v8 w=0.42 l=0.17
XB7_20 VGND WL_7 nc_7_20 VGND sky130_fd_pr__nfet_01v8 w=0.42 l=0.17
XB7_21 VGND WL_7 nc_7_21 VGND sky130_fd_pr__nfet_01v8 w=0.42 l=0.17
XB7_22 VGND WL_7 nc_7_22 VGND sky130_fd_pr__nfet_01v8 w=0.42 l=0.17
XB7_23 VGND WL_7 BLN_23 VGND sky130_fd_pr__nfet_01v8 w=0.42 l=0.17
XB7_24 VGND WL_7 BLN_24 VGND sky130_fd_pr__nfet_01v8 w=0.42 l=0.17
XB7_25 VGND WL_7 BLP_25 VGND sky130_fd_pr__nfet_01v8 w=0.42 l=0.17
XB7_26 VGND WL_7 nc_7_26 VGND sky130_fd_pr__nfet_01v8 w=0.42 l=0.17
XB7_27 VGND WL_7 nc_7_27 VGND sky130_fd_pr__nfet_01v8 w=0.42 l=0.17
XB7_28 VGND WL_7 BLN_28 VGND sky130_fd_pr__nfet_01v8 w=0.42 l=0.17
XB7_29 VGND WL_7 nc_7_29 VGND sky130_fd_pr__nfet_01v8 w=0.42 l=0.17
XB7_30 VGND WL_7 nc_7_30 VGND sky130_fd_pr__nfet_01v8 w=0.42 l=0.17
XB7_31 VGND WL_7 nc_7_31 VGND sky130_fd_pr__nfet_01v8 w=0.42 l=0.17
XB8_0 VGND WL_8 BLN_0 VGND sky130_fd_pr__nfet_01v8 w=0.42 l=0.17
XB8_1 VGND WL_8 BLN_1 VGND sky130_fd_pr__nfet_01v8 w=0.42 l=0.17
XB8_2 VGND WL_8 nc_8_2 VGND sky130_fd_pr__nfet_01v8 w=0.42 l=0.17
XB8_3 VGND WL_8 nc_8_3 VGND sky130_fd_pr__nfet_01v8 w=0.42 l=0.17
XB8_4 VGND WL_8 nc_8_4 VGND sky130_fd_pr__nfet_01v8 w=0.42 l=0.17
XB8_5 VGND WL_8 nc_8_5 VGND sky130_fd_pr__nfet_01v8 w=0.42 l=0.17
XB8_6 VGND WL_8 BLN_6 VGND sky130_fd_pr__nfet_01v8 w=0.42 l=0.17
XB8_7 VGND WL_8 BLN_7 VGND sky130_fd_pr__nfet_01v8 w=0.42 l=0.17
XB8_8 VGND WL_8 BLP_8 VGND sky130_fd_pr__nfet_01v8 w=0.42 l=0.17
XB8_9 VGND WL_8 nc_8_9 VGND sky130_fd_pr__nfet_01v8 w=0.42 l=0.17
XB8_10 VGND WL_8 nc_8_10 VGND sky130_fd_pr__nfet_01v8 w=0.42 l=0.17
XB8_11 VGND WL_8 nc_8_11 VGND sky130_fd_pr__nfet_01v8 w=0.42 l=0.17
XB8_12 VGND WL_8 nc_8_12 VGND sky130_fd_pr__nfet_01v8 w=0.42 l=0.17
XB8_13 VGND WL_8 nc_8_13 VGND sky130_fd_pr__nfet_01v8 w=0.42 l=0.17
XB8_14 VGND WL_8 nc_8_14 VGND sky130_fd_pr__nfet_01v8 w=0.42 l=0.17
XB8_15 VGND WL_8 nc_8_15 VGND sky130_fd_pr__nfet_01v8 w=0.42 l=0.17
XB8_16 VGND WL_8 BLN_16 VGND sky130_fd_pr__nfet_01v8 w=0.42 l=0.17
XB8_17 VGND WL_8 nc_8_17 VGND sky130_fd_pr__nfet_01v8 w=0.42 l=0.17
XB8_18 VGND WL_8 nc_8_18 VGND sky130_fd_pr__nfet_01v8 w=0.42 l=0.17
XB8_19 VGND WL_8 nc_8_19 VGND sky130_fd_pr__nfet_01v8 w=0.42 l=0.17
XB8_20 VGND WL_8 nc_8_20 VGND sky130_fd_pr__nfet_01v8 w=0.42 l=0.17
XB8_21 VGND WL_8 BLP_21 VGND sky130_fd_pr__nfet_01v8 w=0.42 l=0.17
XB8_22 VGND WL_8 nc_8_22 VGND sky130_fd_pr__nfet_01v8 w=0.42 l=0.17
XB8_23 VGND WL_8 BLN_23 VGND sky130_fd_pr__nfet_01v8 w=0.42 l=0.17
XB8_24 VGND WL_8 nc_8_24 VGND sky130_fd_pr__nfet_01v8 w=0.42 l=0.17
XB8_25 VGND WL_8 nc_8_25 VGND sky130_fd_pr__nfet_01v8 w=0.42 l=0.17
XB8_26 VGND WL_8 nc_8_26 VGND sky130_fd_pr__nfet_01v8 w=0.42 l=0.17
XB8_27 VGND WL_8 BLP_27 VGND sky130_fd_pr__nfet_01v8 w=0.42 l=0.17
XB8_28 VGND WL_8 BLP_28 VGND sky130_fd_pr__nfet_01v8 w=0.42 l=0.17
XB8_29 VGND WL_8 BLN_29 VGND sky130_fd_pr__nfet_01v8 w=0.42 l=0.17
XB8_30 VGND WL_8 BLN_30 VGND sky130_fd_pr__nfet_01v8 w=0.42 l=0.17
XB8_31 VGND WL_8 BLN_31 VGND sky130_fd_pr__nfet_01v8 w=0.42 l=0.17
XB9_0 VGND WL_9 BLP_0 VGND sky130_fd_pr__nfet_01v8 w=0.42 l=0.17
XB9_1 VGND WL_9 nc_9_1 VGND sky130_fd_pr__nfet_01v8 w=0.42 l=0.17
XB9_2 VGND WL_9 BLP_2 VGND sky130_fd_pr__nfet_01v8 w=0.42 l=0.17
XB9_3 VGND WL_9 BLN_3 VGND sky130_fd_pr__nfet_01v8 w=0.42 l=0.17
XB9_4 VGND WL_9 BLN_4 VGND sky130_fd_pr__nfet_01v8 w=0.42 l=0.17
XB9_5 VGND WL_9 BLN_5 VGND sky130_fd_pr__nfet_01v8 w=0.42 l=0.17
XB9_6 VGND WL_9 BLN_6 VGND sky130_fd_pr__nfet_01v8 w=0.42 l=0.17
XB9_7 VGND WL_9 BLP_7 VGND sky130_fd_pr__nfet_01v8 w=0.42 l=0.17
XB9_8 VGND WL_9 BLP_8 VGND sky130_fd_pr__nfet_01v8 w=0.42 l=0.17
XB9_9 VGND WL_9 nc_9_9 VGND sky130_fd_pr__nfet_01v8 w=0.42 l=0.17
XB9_10 VGND WL_9 nc_9_10 VGND sky130_fd_pr__nfet_01v8 w=0.42 l=0.17
XB9_11 VGND WL_9 nc_9_11 VGND sky130_fd_pr__nfet_01v8 w=0.42 l=0.17
XB9_12 VGND WL_9 nc_9_12 VGND sky130_fd_pr__nfet_01v8 w=0.42 l=0.17
XB9_13 VGND WL_9 nc_9_13 VGND sky130_fd_pr__nfet_01v8 w=0.42 l=0.17
XB9_14 VGND WL_9 nc_9_14 VGND sky130_fd_pr__nfet_01v8 w=0.42 l=0.17
XB9_15 VGND WL_9 BLP_15 VGND sky130_fd_pr__nfet_01v8 w=0.42 l=0.17
XB9_16 VGND WL_9 nc_9_16 VGND sky130_fd_pr__nfet_01v8 w=0.42 l=0.17
XB9_17 VGND WL_9 nc_9_17 VGND sky130_fd_pr__nfet_01v8 w=0.42 l=0.17
XB9_18 VGND WL_9 nc_9_18 VGND sky130_fd_pr__nfet_01v8 w=0.42 l=0.17
XB9_19 VGND WL_9 nc_9_19 VGND sky130_fd_pr__nfet_01v8 w=0.42 l=0.17
XB9_20 VGND WL_9 nc_9_20 VGND sky130_fd_pr__nfet_01v8 w=0.42 l=0.17
XB9_21 VGND WL_9 BLP_21 VGND sky130_fd_pr__nfet_01v8 w=0.42 l=0.17
XB9_22 VGND WL_9 BLP_22 VGND sky130_fd_pr__nfet_01v8 w=0.42 l=0.17
XB9_23 VGND WL_9 nc_9_23 VGND sky130_fd_pr__nfet_01v8 w=0.42 l=0.17
XB9_24 VGND WL_9 nc_9_24 VGND sky130_fd_pr__nfet_01v8 w=0.42 l=0.17
XB9_25 VGND WL_9 nc_9_25 VGND sky130_fd_pr__nfet_01v8 w=0.42 l=0.17
XB9_26 VGND WL_9 nc_9_26 VGND sky130_fd_pr__nfet_01v8 w=0.42 l=0.17
XB9_27 VGND WL_9 nc_9_27 VGND sky130_fd_pr__nfet_01v8 w=0.42 l=0.17
XB9_28 VGND WL_9 BLN_28 VGND sky130_fd_pr__nfet_01v8 w=0.42 l=0.17
XB9_29 VGND WL_9 BLN_29 VGND sky130_fd_pr__nfet_01v8 w=0.42 l=0.17
XB9_30 VGND WL_9 BLN_30 VGND sky130_fd_pr__nfet_01v8 w=0.42 l=0.17
XB9_31 VGND WL_9 nc_9_31 VGND sky130_fd_pr__nfet_01v8 w=0.42 l=0.17
XB10_0 VGND WL_10 BLN_0 VGND sky130_fd_pr__nfet_01v8 w=0.42 l=0.17
XB10_1 VGND WL_10 nc_10_1 VGND sky130_fd_pr__nfet_01v8 w=0.42 l=0.17
XB10_2 VGND WL_10 nc_10_2 VGND sky130_fd_pr__nfet_01v8 w=0.42 l=0.17
XB10_3 VGND WL_10 BLP_3 VGND sky130_fd_pr__nfet_01v8 w=0.42 l=0.17
XB10_4 VGND WL_10 BLN_4 VGND sky130_fd_pr__nfet_01v8 w=0.42 l=0.17
XB10_5 VGND WL_10 nc_10_5 VGND sky130_fd_pr__nfet_01v8 w=0.42 l=0.17
XB10_6 VGND WL_10 nc_10_6 VGND sky130_fd_pr__nfet_01v8 w=0.42 l=0.17
XB10_7 VGND WL_10 nc_10_7 VGND sky130_fd_pr__nfet_01v8 w=0.42 l=0.17
XB10_8 VGND WL_10 BLN_8 VGND sky130_fd_pr__nfet_01v8 w=0.42 l=0.17
XB10_9 VGND WL_10 nc_10_9 VGND sky130_fd_pr__nfet_01v8 w=0.42 l=0.17
XB10_10 VGND WL_10 BLP_10 VGND sky130_fd_pr__nfet_01v8 w=0.42 l=0.17
XB10_11 VGND WL_10 BLN_11 VGND sky130_fd_pr__nfet_01v8 w=0.42 l=0.17
XB10_12 VGND WL_10 BLN_12 VGND sky130_fd_pr__nfet_01v8 w=0.42 l=0.17
XB10_13 VGND WL_10 nc_10_13 VGND sky130_fd_pr__nfet_01v8 w=0.42 l=0.17
XB10_14 VGND WL_10 nc_10_14 VGND sky130_fd_pr__nfet_01v8 w=0.42 l=0.17
XB10_15 VGND WL_10 BLN_15 VGND sky130_fd_pr__nfet_01v8 w=0.42 l=0.17
XB10_16 VGND WL_10 nc_10_16 VGND sky130_fd_pr__nfet_01v8 w=0.42 l=0.17
XB10_17 VGND WL_10 nc_10_17 VGND sky130_fd_pr__nfet_01v8 w=0.42 l=0.17
XB10_18 VGND WL_10 nc_10_18 VGND sky130_fd_pr__nfet_01v8 w=0.42 l=0.17
XB10_19 VGND WL_10 nc_10_19 VGND sky130_fd_pr__nfet_01v8 w=0.42 l=0.17
XB10_20 VGND WL_10 nc_10_20 VGND sky130_fd_pr__nfet_01v8 w=0.42 l=0.17
XB10_21 VGND WL_10 BLN_21 VGND sky130_fd_pr__nfet_01v8 w=0.42 l=0.17
XB10_22 VGND WL_10 nc_10_22 VGND sky130_fd_pr__nfet_01v8 w=0.42 l=0.17
XB10_23 VGND WL_10 nc_10_23 VGND sky130_fd_pr__nfet_01v8 w=0.42 l=0.17
XB10_24 VGND WL_10 BLP_24 VGND sky130_fd_pr__nfet_01v8 w=0.42 l=0.17
XB10_25 VGND WL_10 nc_10_25 VGND sky130_fd_pr__nfet_01v8 w=0.42 l=0.17
XB10_26 VGND WL_10 nc_10_26 VGND sky130_fd_pr__nfet_01v8 w=0.42 l=0.17
XB10_27 VGND WL_10 nc_10_27 VGND sky130_fd_pr__nfet_01v8 w=0.42 l=0.17
XB10_28 VGND WL_10 nc_10_28 VGND sky130_fd_pr__nfet_01v8 w=0.42 l=0.17
XB10_29 VGND WL_10 BLN_29 VGND sky130_fd_pr__nfet_01v8 w=0.42 l=0.17
XB10_30 VGND WL_10 nc_10_30 VGND sky130_fd_pr__nfet_01v8 w=0.42 l=0.17
XB10_31 VGND WL_10 nc_10_31 VGND sky130_fd_pr__nfet_01v8 w=0.42 l=0.17
XB11_0 VGND WL_11 BLN_0 VGND sky130_fd_pr__nfet_01v8 w=0.42 l=0.17
XB11_1 VGND WL_11 nc_11_1 VGND sky130_fd_pr__nfet_01v8 w=0.42 l=0.17
XB11_2 VGND WL_11 BLN_2 VGND sky130_fd_pr__nfet_01v8 w=0.42 l=0.17
XB11_3 VGND WL_11 nc_11_3 VGND sky130_fd_pr__nfet_01v8 w=0.42 l=0.17
XB11_4 VGND WL_11 nc_11_4 VGND sky130_fd_pr__nfet_01v8 w=0.42 l=0.17
XB11_5 VGND WL_11 BLN_5 VGND sky130_fd_pr__nfet_01v8 w=0.42 l=0.17
XB11_6 VGND WL_11 nc_11_6 VGND sky130_fd_pr__nfet_01v8 w=0.42 l=0.17
XB11_7 VGND WL_11 BLP_7 VGND sky130_fd_pr__nfet_01v8 w=0.42 l=0.17
XB11_8 VGND WL_11 nc_11_8 VGND sky130_fd_pr__nfet_01v8 w=0.42 l=0.17
XB11_9 VGND WL_11 nc_11_9 VGND sky130_fd_pr__nfet_01v8 w=0.42 l=0.17
XB11_10 VGND WL_11 nc_11_10 VGND sky130_fd_pr__nfet_01v8 w=0.42 l=0.17
XB11_11 VGND WL_11 BLN_11 VGND sky130_fd_pr__nfet_01v8 w=0.42 l=0.17
XB11_12 VGND WL_11 BLN_12 VGND sky130_fd_pr__nfet_01v8 w=0.42 l=0.17
XB11_13 VGND WL_11 BLP_13 VGND sky130_fd_pr__nfet_01v8 w=0.42 l=0.17
XB11_14 VGND WL_11 BLN_14 VGND sky130_fd_pr__nfet_01v8 w=0.42 l=0.17
XB11_15 VGND WL_11 nc_11_15 VGND sky130_fd_pr__nfet_01v8 w=0.42 l=0.17
XB11_16 VGND WL_11 BLP_16 VGND sky130_fd_pr__nfet_01v8 w=0.42 l=0.17
XB11_17 VGND WL_11 BLN_17 VGND sky130_fd_pr__nfet_01v8 w=0.42 l=0.17
XB11_18 VGND WL_11 BLN_18 VGND sky130_fd_pr__nfet_01v8 w=0.42 l=0.17
XB11_19 VGND WL_11 nc_11_19 VGND sky130_fd_pr__nfet_01v8 w=0.42 l=0.17
XB11_20 VGND WL_11 BLP_20 VGND sky130_fd_pr__nfet_01v8 w=0.42 l=0.17
XB11_21 VGND WL_11 BLN_21 VGND sky130_fd_pr__nfet_01v8 w=0.42 l=0.17
XB11_22 VGND WL_11 nc_11_22 VGND sky130_fd_pr__nfet_01v8 w=0.42 l=0.17
XB11_23 VGND WL_11 BLP_23 VGND sky130_fd_pr__nfet_01v8 w=0.42 l=0.17
XB11_24 VGND WL_11 BLN_24 VGND sky130_fd_pr__nfet_01v8 w=0.42 l=0.17
XB11_25 VGND WL_11 BLP_25 VGND sky130_fd_pr__nfet_01v8 w=0.42 l=0.17
XB11_26 VGND WL_11 nc_11_26 VGND sky130_fd_pr__nfet_01v8 w=0.42 l=0.17
XB11_27 VGND WL_11 BLN_27 VGND sky130_fd_pr__nfet_01v8 w=0.42 l=0.17
XB11_28 VGND WL_11 BLN_28 VGND sky130_fd_pr__nfet_01v8 w=0.42 l=0.17
XB11_29 VGND WL_11 nc_11_29 VGND sky130_fd_pr__nfet_01v8 w=0.42 l=0.17
XB11_30 VGND WL_11 nc_11_30 VGND sky130_fd_pr__nfet_01v8 w=0.42 l=0.17
XB11_31 VGND WL_11 BLP_31 VGND sky130_fd_pr__nfet_01v8 w=0.42 l=0.17
XB12_0 VGND WL_12 BLN_0 VGND sky130_fd_pr__nfet_01v8 w=0.42 l=0.17
XB12_1 VGND WL_12 nc_12_1 VGND sky130_fd_pr__nfet_01v8 w=0.42 l=0.17
XB12_2 VGND WL_12 nc_12_2 VGND sky130_fd_pr__nfet_01v8 w=0.42 l=0.17
XB12_3 VGND WL_12 BLN_3 VGND sky130_fd_pr__nfet_01v8 w=0.42 l=0.17
XB12_4 VGND WL_12 BLP_4 VGND sky130_fd_pr__nfet_01v8 w=0.42 l=0.17
XB12_5 VGND WL_12 nc_12_5 VGND sky130_fd_pr__nfet_01v8 w=0.42 l=0.17
XB12_6 VGND WL_12 BLP_6 VGND sky130_fd_pr__nfet_01v8 w=0.42 l=0.17
XB12_7 VGND WL_12 BLN_7 VGND sky130_fd_pr__nfet_01v8 w=0.42 l=0.17
XB12_8 VGND WL_12 nc_12_8 VGND sky130_fd_pr__nfet_01v8 w=0.42 l=0.17
XB12_9 VGND WL_12 nc_12_9 VGND sky130_fd_pr__nfet_01v8 w=0.42 l=0.17
XB12_10 VGND WL_12 nc_12_10 VGND sky130_fd_pr__nfet_01v8 w=0.42 l=0.17
XB12_11 VGND WL_12 BLN_11 VGND sky130_fd_pr__nfet_01v8 w=0.42 l=0.17
XB12_12 VGND WL_12 BLN_12 VGND sky130_fd_pr__nfet_01v8 w=0.42 l=0.17
XB12_13 VGND WL_12 nc_12_13 VGND sky130_fd_pr__nfet_01v8 w=0.42 l=0.17
XB12_14 VGND WL_12 BLN_14 VGND sky130_fd_pr__nfet_01v8 w=0.42 l=0.17
XB12_15 VGND WL_12 nc_12_15 VGND sky130_fd_pr__nfet_01v8 w=0.42 l=0.17
XB12_16 VGND WL_12 BLN_16 VGND sky130_fd_pr__nfet_01v8 w=0.42 l=0.17
XB12_17 VGND WL_12 BLP_17 VGND sky130_fd_pr__nfet_01v8 w=0.42 l=0.17
XB12_18 VGND WL_12 nc_12_18 VGND sky130_fd_pr__nfet_01v8 w=0.42 l=0.17
XB12_19 VGND WL_12 BLN_19 VGND sky130_fd_pr__nfet_01v8 w=0.42 l=0.17
XB12_20 VGND WL_12 nc_12_20 VGND sky130_fd_pr__nfet_01v8 w=0.42 l=0.17
XB12_21 VGND WL_12 BLP_21 VGND sky130_fd_pr__nfet_01v8 w=0.42 l=0.17
XB12_22 VGND WL_12 BLP_22 VGND sky130_fd_pr__nfet_01v8 w=0.42 l=0.17
XB12_23 VGND WL_12 BLN_23 VGND sky130_fd_pr__nfet_01v8 w=0.42 l=0.17
XB12_24 VGND WL_12 BLP_24 VGND sky130_fd_pr__nfet_01v8 w=0.42 l=0.17
XB12_25 VGND WL_12 nc_12_25 VGND sky130_fd_pr__nfet_01v8 w=0.42 l=0.17
XB12_26 VGND WL_12 BLP_26 VGND sky130_fd_pr__nfet_01v8 w=0.42 l=0.17
XB12_27 VGND WL_12 BLP_27 VGND sky130_fd_pr__nfet_01v8 w=0.42 l=0.17
XB12_28 VGND WL_12 nc_12_28 VGND sky130_fd_pr__nfet_01v8 w=0.42 l=0.17
XB12_29 VGND WL_12 nc_12_29 VGND sky130_fd_pr__nfet_01v8 w=0.42 l=0.17
XB12_30 VGND WL_12 nc_12_30 VGND sky130_fd_pr__nfet_01v8 w=0.42 l=0.17
XB12_31 VGND WL_12 nc_12_31 VGND sky130_fd_pr__nfet_01v8 w=0.42 l=0.17
XB13_0 VGND WL_13 BLN_0 VGND sky130_fd_pr__nfet_01v8 w=0.42 l=0.17
XB13_1 VGND WL_13 BLN_1 VGND sky130_fd_pr__nfet_01v8 w=0.42 l=0.17
XB13_2 VGND WL_13 nc_13_2 VGND sky130_fd_pr__nfet_01v8 w=0.42 l=0.17
XB13_3 VGND WL_13 nc_13_3 VGND sky130_fd_pr__nfet_01v8 w=0.42 l=0.17
XB13_4 VGND WL_13 nc_13_4 VGND sky130_fd_pr__nfet_01v8 w=0.42 l=0.17
XB13_5 VGND WL_13 BLP_5 VGND sky130_fd_pr__nfet_01v8 w=0.42 l=0.17
XB13_6 VGND WL_13 nc_13_6 VGND sky130_fd_pr__nfet_01v8 w=0.42 l=0.17
XB13_7 VGND WL_13 nc_13_7 VGND sky130_fd_pr__nfet_01v8 w=0.42 l=0.17
XB13_8 VGND WL_13 BLN_8 VGND sky130_fd_pr__nfet_01v8 w=0.42 l=0.17
XB13_9 VGND WL_13 BLN_9 VGND sky130_fd_pr__nfet_01v8 w=0.42 l=0.17
XB13_10 VGND WL_13 BLN_10 VGND sky130_fd_pr__nfet_01v8 w=0.42 l=0.17
XB13_11 VGND WL_13 BLP_11 VGND sky130_fd_pr__nfet_01v8 w=0.42 l=0.17
XB13_12 VGND WL_13 BLN_12 VGND sky130_fd_pr__nfet_01v8 w=0.42 l=0.17
XB13_13 VGND WL_13 nc_13_13 VGND sky130_fd_pr__nfet_01v8 w=0.42 l=0.17
XB13_14 VGND WL_13 nc_13_14 VGND sky130_fd_pr__nfet_01v8 w=0.42 l=0.17
XB13_15 VGND WL_13 nc_13_15 VGND sky130_fd_pr__nfet_01v8 w=0.42 l=0.17
XB13_16 VGND WL_13 BLN_16 VGND sky130_fd_pr__nfet_01v8 w=0.42 l=0.17
XB13_17 VGND WL_13 BLP_17 VGND sky130_fd_pr__nfet_01v8 w=0.42 l=0.17
XB13_18 VGND WL_13 nc_13_18 VGND sky130_fd_pr__nfet_01v8 w=0.42 l=0.17
XB13_19 VGND WL_13 nc_13_19 VGND sky130_fd_pr__nfet_01v8 w=0.42 l=0.17
XB13_20 VGND WL_13 nc_13_20 VGND sky130_fd_pr__nfet_01v8 w=0.42 l=0.17
XB13_21 VGND WL_13 BLN_21 VGND sky130_fd_pr__nfet_01v8 w=0.42 l=0.17
XB13_22 VGND WL_13 nc_13_22 VGND sky130_fd_pr__nfet_01v8 w=0.42 l=0.17
XB13_23 VGND WL_13 nc_13_23 VGND sky130_fd_pr__nfet_01v8 w=0.42 l=0.17
XB13_24 VGND WL_13 BLP_24 VGND sky130_fd_pr__nfet_01v8 w=0.42 l=0.17
XB13_25 VGND WL_13 BLN_25 VGND sky130_fd_pr__nfet_01v8 w=0.42 l=0.17
XB13_26 VGND WL_13 nc_13_26 VGND sky130_fd_pr__nfet_01v8 w=0.42 l=0.17
XB13_27 VGND WL_13 nc_13_27 VGND sky130_fd_pr__nfet_01v8 w=0.42 l=0.17
XB13_28 VGND WL_13 nc_13_28 VGND sky130_fd_pr__nfet_01v8 w=0.42 l=0.17
XB13_29 VGND WL_13 nc_13_29 VGND sky130_fd_pr__nfet_01v8 w=0.42 l=0.17
XB13_30 VGND WL_13 nc_13_30 VGND sky130_fd_pr__nfet_01v8 w=0.42 l=0.17
XB13_31 VGND WL_13 nc_13_31 VGND sky130_fd_pr__nfet_01v8 w=0.42 l=0.17
XB14_0 VGND WL_14 BLN_0 VGND sky130_fd_pr__nfet_01v8 w=0.42 l=0.17
XB14_1 VGND WL_14 BLN_1 VGND sky130_fd_pr__nfet_01v8 w=0.42 l=0.17
XB14_2 VGND WL_14 BLN_2 VGND sky130_fd_pr__nfet_01v8 w=0.42 l=0.17
XB14_3 VGND WL_14 BLN_3 VGND sky130_fd_pr__nfet_01v8 w=0.42 l=0.17
XB14_4 VGND WL_14 BLN_4 VGND sky130_fd_pr__nfet_01v8 w=0.42 l=0.17
XB14_5 VGND WL_14 nc_14_5 VGND sky130_fd_pr__nfet_01v8 w=0.42 l=0.17
XB14_6 VGND WL_14 BLP_6 VGND sky130_fd_pr__nfet_01v8 w=0.42 l=0.17
XB14_7 VGND WL_14 nc_14_7 VGND sky130_fd_pr__nfet_01v8 w=0.42 l=0.17
XB14_8 VGND WL_14 BLN_8 VGND sky130_fd_pr__nfet_01v8 w=0.42 l=0.17
XB14_9 VGND WL_14 BLP_9 VGND sky130_fd_pr__nfet_01v8 w=0.42 l=0.17
XB14_10 VGND WL_14 BLP_10 VGND sky130_fd_pr__nfet_01v8 w=0.42 l=0.17
XB14_11 VGND WL_14 BLP_11 VGND sky130_fd_pr__nfet_01v8 w=0.42 l=0.17
XB14_12 VGND WL_14 BLN_12 VGND sky130_fd_pr__nfet_01v8 w=0.42 l=0.17
XB14_13 VGND WL_14 nc_14_13 VGND sky130_fd_pr__nfet_01v8 w=0.42 l=0.17
XB14_14 VGND WL_14 BLN_14 VGND sky130_fd_pr__nfet_01v8 w=0.42 l=0.17
XB14_15 VGND WL_14 BLP_15 VGND sky130_fd_pr__nfet_01v8 w=0.42 l=0.17
XB14_16 VGND WL_14 BLP_16 VGND sky130_fd_pr__nfet_01v8 w=0.42 l=0.17
XB14_17 VGND WL_14 nc_14_17 VGND sky130_fd_pr__nfet_01v8 w=0.42 l=0.17
XB14_18 VGND WL_14 BLN_18 VGND sky130_fd_pr__nfet_01v8 w=0.42 l=0.17
XB14_19 VGND WL_14 BLN_19 VGND sky130_fd_pr__nfet_01v8 w=0.42 l=0.17
XB14_20 VGND WL_14 BLP_20 VGND sky130_fd_pr__nfet_01v8 w=0.42 l=0.17
XB14_21 VGND WL_14 nc_14_21 VGND sky130_fd_pr__nfet_01v8 w=0.42 l=0.17
XB14_22 VGND WL_14 nc_14_22 VGND sky130_fd_pr__nfet_01v8 w=0.42 l=0.17
XB14_23 VGND WL_14 BLN_23 VGND sky130_fd_pr__nfet_01v8 w=0.42 l=0.17
XB14_24 VGND WL_14 nc_14_24 VGND sky130_fd_pr__nfet_01v8 w=0.42 l=0.17
XB14_25 VGND WL_14 BLN_25 VGND sky130_fd_pr__nfet_01v8 w=0.42 l=0.17
XB14_26 VGND WL_14 nc_14_26 VGND sky130_fd_pr__nfet_01v8 w=0.42 l=0.17
XB14_27 VGND WL_14 BLP_27 VGND sky130_fd_pr__nfet_01v8 w=0.42 l=0.17
XB14_28 VGND WL_14 nc_14_28 VGND sky130_fd_pr__nfet_01v8 w=0.42 l=0.17
XB14_29 VGND WL_14 nc_14_29 VGND sky130_fd_pr__nfet_01v8 w=0.42 l=0.17
XB14_30 VGND WL_14 BLP_30 VGND sky130_fd_pr__nfet_01v8 w=0.42 l=0.17
XB14_31 VGND WL_14 BLN_31 VGND sky130_fd_pr__nfet_01v8 w=0.42 l=0.17
XB15_0 VGND WL_15 BLN_0 VGND sky130_fd_pr__nfet_01v8 w=0.42 l=0.17
XB15_1 VGND WL_15 BLP_1 VGND sky130_fd_pr__nfet_01v8 w=0.42 l=0.17
XB15_2 VGND WL_15 nc_15_2 VGND sky130_fd_pr__nfet_01v8 w=0.42 l=0.17
XB15_3 VGND WL_15 BLP_3 VGND sky130_fd_pr__nfet_01v8 w=0.42 l=0.17
XB15_4 VGND WL_15 nc_15_4 VGND sky130_fd_pr__nfet_01v8 w=0.42 l=0.17
XB15_5 VGND WL_15 BLN_5 VGND sky130_fd_pr__nfet_01v8 w=0.42 l=0.17
XB15_6 VGND WL_15 nc_15_6 VGND sky130_fd_pr__nfet_01v8 w=0.42 l=0.17
XB15_7 VGND WL_15 BLN_7 VGND sky130_fd_pr__nfet_01v8 w=0.42 l=0.17
XB15_8 VGND WL_15 nc_15_8 VGND sky130_fd_pr__nfet_01v8 w=0.42 l=0.17
XB15_9 VGND WL_15 nc_15_9 VGND sky130_fd_pr__nfet_01v8 w=0.42 l=0.17
XB15_10 VGND WL_15 BLP_10 VGND sky130_fd_pr__nfet_01v8 w=0.42 l=0.17
XB15_11 VGND WL_15 BLP_11 VGND sky130_fd_pr__nfet_01v8 w=0.42 l=0.17
XB15_12 VGND WL_15 nc_15_12 VGND sky130_fd_pr__nfet_01v8 w=0.42 l=0.17
XB15_13 VGND WL_15 BLN_13 VGND sky130_fd_pr__nfet_01v8 w=0.42 l=0.17
XB15_14 VGND WL_15 BLP_14 VGND sky130_fd_pr__nfet_01v8 w=0.42 l=0.17
XB15_15 VGND WL_15 BLP_15 VGND sky130_fd_pr__nfet_01v8 w=0.42 l=0.17
XB15_16 VGND WL_15 nc_15_16 VGND sky130_fd_pr__nfet_01v8 w=0.42 l=0.17
XB15_17 VGND WL_15 nc_15_17 VGND sky130_fd_pr__nfet_01v8 w=0.42 l=0.17
XB15_18 VGND WL_15 nc_15_18 VGND sky130_fd_pr__nfet_01v8 w=0.42 l=0.17
XB15_19 VGND WL_15 BLP_19 VGND sky130_fd_pr__nfet_01v8 w=0.42 l=0.17
XB15_20 VGND WL_15 nc_15_20 VGND sky130_fd_pr__nfet_01v8 w=0.42 l=0.17
XB15_21 VGND WL_15 BLP_21 VGND sky130_fd_pr__nfet_01v8 w=0.42 l=0.17
XB15_22 VGND WL_15 BLP_22 VGND sky130_fd_pr__nfet_01v8 w=0.42 l=0.17
XB15_23 VGND WL_15 BLN_23 VGND sky130_fd_pr__nfet_01v8 w=0.42 l=0.17
XB15_24 VGND WL_15 BLN_24 VGND sky130_fd_pr__nfet_01v8 w=0.42 l=0.17
XB15_25 VGND WL_15 nc_15_25 VGND sky130_fd_pr__nfet_01v8 w=0.42 l=0.17
XB15_26 VGND WL_15 BLP_26 VGND sky130_fd_pr__nfet_01v8 w=0.42 l=0.17
XB15_27 VGND WL_15 nc_15_27 VGND sky130_fd_pr__nfet_01v8 w=0.42 l=0.17
XB15_28 VGND WL_15 BLP_28 VGND sky130_fd_pr__nfet_01v8 w=0.42 l=0.17
XB15_29 VGND WL_15 nc_15_29 VGND sky130_fd_pr__nfet_01v8 w=0.42 l=0.17
XB15_30 VGND WL_15 BLP_30 VGND sky130_fd_pr__nfet_01v8 w=0.42 l=0.17
XB15_31 VGND WL_15 BLP_31 VGND sky130_fd_pr__nfet_01v8 w=0.42 l=0.17
XB16_0 VGND WL_16 nc_16_0 VGND sky130_fd_pr__nfet_01v8 w=0.42 l=0.17
XB16_1 VGND WL_16 BLP_1 VGND sky130_fd_pr__nfet_01v8 w=0.42 l=0.17
XB16_2 VGND WL_16 BLP_2 VGND sky130_fd_pr__nfet_01v8 w=0.42 l=0.17
XB16_3 VGND WL_16 nc_16_3 VGND sky130_fd_pr__nfet_01v8 w=0.42 l=0.17
XB16_4 VGND WL_16 BLN_4 VGND sky130_fd_pr__nfet_01v8 w=0.42 l=0.17
XB16_5 VGND WL_16 nc_16_5 VGND sky130_fd_pr__nfet_01v8 w=0.42 l=0.17
XB16_6 VGND WL_16 BLP_6 VGND sky130_fd_pr__nfet_01v8 w=0.42 l=0.17
XB16_7 VGND WL_16 BLN_7 VGND sky130_fd_pr__nfet_01v8 w=0.42 l=0.17
XB16_8 VGND WL_16 BLN_8 VGND sky130_fd_pr__nfet_01v8 w=0.42 l=0.17
XB16_9 VGND WL_16 BLP_9 VGND sky130_fd_pr__nfet_01v8 w=0.42 l=0.17
XB16_10 VGND WL_16 nc_16_10 VGND sky130_fd_pr__nfet_01v8 w=0.42 l=0.17
XB16_11 VGND WL_16 BLN_11 VGND sky130_fd_pr__nfet_01v8 w=0.42 l=0.17
XB16_12 VGND WL_16 BLP_12 VGND sky130_fd_pr__nfet_01v8 w=0.42 l=0.17
XB16_13 VGND WL_16 BLN_13 VGND sky130_fd_pr__nfet_01v8 w=0.42 l=0.17
XB16_14 VGND WL_16 BLP_14 VGND sky130_fd_pr__nfet_01v8 w=0.42 l=0.17
XB16_15 VGND WL_16 BLP_15 VGND sky130_fd_pr__nfet_01v8 w=0.42 l=0.17
XB16_16 VGND WL_16 BLN_16 VGND sky130_fd_pr__nfet_01v8 w=0.42 l=0.17
XB16_17 VGND WL_16 nc_16_17 VGND sky130_fd_pr__nfet_01v8 w=0.42 l=0.17
XB16_18 VGND WL_16 BLN_18 VGND sky130_fd_pr__nfet_01v8 w=0.42 l=0.17
XB16_19 VGND WL_16 nc_16_19 VGND sky130_fd_pr__nfet_01v8 w=0.42 l=0.17
XB16_20 VGND WL_16 BLP_20 VGND sky130_fd_pr__nfet_01v8 w=0.42 l=0.17
XB16_21 VGND WL_16 nc_16_21 VGND sky130_fd_pr__nfet_01v8 w=0.42 l=0.17
XB16_22 VGND WL_16 nc_16_22 VGND sky130_fd_pr__nfet_01v8 w=0.42 l=0.17
XB16_23 VGND WL_16 BLP_23 VGND sky130_fd_pr__nfet_01v8 w=0.42 l=0.17
XB16_24 VGND WL_16 BLN_24 VGND sky130_fd_pr__nfet_01v8 w=0.42 l=0.17
XB16_25 VGND WL_16 nc_16_25 VGND sky130_fd_pr__nfet_01v8 w=0.42 l=0.17
XB16_26 VGND WL_16 nc_16_26 VGND sky130_fd_pr__nfet_01v8 w=0.42 l=0.17
XB16_27 VGND WL_16 BLP_27 VGND sky130_fd_pr__nfet_01v8 w=0.42 l=0.17
XB16_28 VGND WL_16 BLN_28 VGND sky130_fd_pr__nfet_01v8 w=0.42 l=0.17
XB16_29 VGND WL_16 nc_16_29 VGND sky130_fd_pr__nfet_01v8 w=0.42 l=0.17
XB16_30 VGND WL_16 BLN_30 VGND sky130_fd_pr__nfet_01v8 w=0.42 l=0.17
XB16_31 VGND WL_16 BLN_31 VGND sky130_fd_pr__nfet_01v8 w=0.42 l=0.17
XB17_0 VGND WL_17 nc_17_0 VGND sky130_fd_pr__nfet_01v8 w=0.42 l=0.17
XB17_1 VGND WL_17 BLP_1 VGND sky130_fd_pr__nfet_01v8 w=0.42 l=0.17
XB17_2 VGND WL_17 nc_17_2 VGND sky130_fd_pr__nfet_01v8 w=0.42 l=0.17
XB17_3 VGND WL_17 nc_17_3 VGND sky130_fd_pr__nfet_01v8 w=0.42 l=0.17
XB17_4 VGND WL_17 BLN_4 VGND sky130_fd_pr__nfet_01v8 w=0.42 l=0.17
XB17_5 VGND WL_17 nc_17_5 VGND sky130_fd_pr__nfet_01v8 w=0.42 l=0.17
XB17_6 VGND WL_17 nc_17_6 VGND sky130_fd_pr__nfet_01v8 w=0.42 l=0.17
XB17_7 VGND WL_17 nc_17_7 VGND sky130_fd_pr__nfet_01v8 w=0.42 l=0.17
XB17_8 VGND WL_17 nc_17_8 VGND sky130_fd_pr__nfet_01v8 w=0.42 l=0.17
XB17_9 VGND WL_17 nc_17_9 VGND sky130_fd_pr__nfet_01v8 w=0.42 l=0.17
XB17_10 VGND WL_17 BLP_10 VGND sky130_fd_pr__nfet_01v8 w=0.42 l=0.17
XB17_11 VGND WL_17 nc_17_11 VGND sky130_fd_pr__nfet_01v8 w=0.42 l=0.17
XB17_12 VGND WL_17 nc_17_12 VGND sky130_fd_pr__nfet_01v8 w=0.42 l=0.17
XB17_13 VGND WL_17 nc_17_13 VGND sky130_fd_pr__nfet_01v8 w=0.42 l=0.17
XB17_14 VGND WL_17 BLP_14 VGND sky130_fd_pr__nfet_01v8 w=0.42 l=0.17
XB17_15 VGND WL_17 BLP_15 VGND sky130_fd_pr__nfet_01v8 w=0.42 l=0.17
XB17_16 VGND WL_17 nc_17_16 VGND sky130_fd_pr__nfet_01v8 w=0.42 l=0.17
XB17_17 VGND WL_17 nc_17_17 VGND sky130_fd_pr__nfet_01v8 w=0.42 l=0.17
XB17_18 VGND WL_17 nc_17_18 VGND sky130_fd_pr__nfet_01v8 w=0.42 l=0.17
XB17_19 VGND WL_17 nc_17_19 VGND sky130_fd_pr__nfet_01v8 w=0.42 l=0.17
XB17_20 VGND WL_17 BLN_20 VGND sky130_fd_pr__nfet_01v8 w=0.42 l=0.17
XB17_21 VGND WL_17 BLP_21 VGND sky130_fd_pr__nfet_01v8 w=0.42 l=0.17
XB17_22 VGND WL_17 nc_17_22 VGND sky130_fd_pr__nfet_01v8 w=0.42 l=0.17
XB17_23 VGND WL_17 BLN_23 VGND sky130_fd_pr__nfet_01v8 w=0.42 l=0.17
XB17_24 VGND WL_17 BLN_24 VGND sky130_fd_pr__nfet_01v8 w=0.42 l=0.17
XB17_25 VGND WL_17 BLP_25 VGND sky130_fd_pr__nfet_01v8 w=0.42 l=0.17
XB17_26 VGND WL_17 BLN_26 VGND sky130_fd_pr__nfet_01v8 w=0.42 l=0.17
XB17_27 VGND WL_17 nc_17_27 VGND sky130_fd_pr__nfet_01v8 w=0.42 l=0.17
XB17_28 VGND WL_17 BLP_28 VGND sky130_fd_pr__nfet_01v8 w=0.42 l=0.17
XB17_29 VGND WL_17 BLP_29 VGND sky130_fd_pr__nfet_01v8 w=0.42 l=0.17
XB17_30 VGND WL_17 nc_17_30 VGND sky130_fd_pr__nfet_01v8 w=0.42 l=0.17
XB17_31 VGND WL_17 BLN_31 VGND sky130_fd_pr__nfet_01v8 w=0.42 l=0.17
XB18_0 VGND WL_18 BLP_0 VGND sky130_fd_pr__nfet_01v8 w=0.42 l=0.17
XB18_1 VGND WL_18 nc_18_1 VGND sky130_fd_pr__nfet_01v8 w=0.42 l=0.17
XB18_2 VGND WL_18 BLN_2 VGND sky130_fd_pr__nfet_01v8 w=0.42 l=0.17
XB18_3 VGND WL_18 nc_18_3 VGND sky130_fd_pr__nfet_01v8 w=0.42 l=0.17
XB18_4 VGND WL_18 BLP_4 VGND sky130_fd_pr__nfet_01v8 w=0.42 l=0.17
XB18_5 VGND WL_18 BLN_5 VGND sky130_fd_pr__nfet_01v8 w=0.42 l=0.17
XB18_6 VGND WL_18 BLP_6 VGND sky130_fd_pr__nfet_01v8 w=0.42 l=0.17
XB18_7 VGND WL_18 BLN_7 VGND sky130_fd_pr__nfet_01v8 w=0.42 l=0.17
XB18_8 VGND WL_18 nc_18_8 VGND sky130_fd_pr__nfet_01v8 w=0.42 l=0.17
XB18_9 VGND WL_18 BLN_9 VGND sky130_fd_pr__nfet_01v8 w=0.42 l=0.17
XB18_10 VGND WL_18 BLN_10 VGND sky130_fd_pr__nfet_01v8 w=0.42 l=0.17
XB18_11 VGND WL_18 nc_18_11 VGND sky130_fd_pr__nfet_01v8 w=0.42 l=0.17
XB18_12 VGND WL_18 BLP_12 VGND sky130_fd_pr__nfet_01v8 w=0.42 l=0.17
XB18_13 VGND WL_18 BLP_13 VGND sky130_fd_pr__nfet_01v8 w=0.42 l=0.17
XB18_14 VGND WL_18 BLN_14 VGND sky130_fd_pr__nfet_01v8 w=0.42 l=0.17
XB18_15 VGND WL_18 nc_18_15 VGND sky130_fd_pr__nfet_01v8 w=0.42 l=0.17
XB18_16 VGND WL_18 BLN_16 VGND sky130_fd_pr__nfet_01v8 w=0.42 l=0.17
XB18_17 VGND WL_18 BLP_17 VGND sky130_fd_pr__nfet_01v8 w=0.42 l=0.17
XB18_18 VGND WL_18 nc_18_18 VGND sky130_fd_pr__nfet_01v8 w=0.42 l=0.17
XB18_19 VGND WL_18 nc_18_19 VGND sky130_fd_pr__nfet_01v8 w=0.42 l=0.17
XB18_20 VGND WL_18 BLP_20 VGND sky130_fd_pr__nfet_01v8 w=0.42 l=0.17
XB18_21 VGND WL_18 BLN_21 VGND sky130_fd_pr__nfet_01v8 w=0.42 l=0.17
XB18_22 VGND WL_18 nc_18_22 VGND sky130_fd_pr__nfet_01v8 w=0.42 l=0.17
XB18_23 VGND WL_18 nc_18_23 VGND sky130_fd_pr__nfet_01v8 w=0.42 l=0.17
XB18_24 VGND WL_18 nc_18_24 VGND sky130_fd_pr__nfet_01v8 w=0.42 l=0.17
XB18_25 VGND WL_18 BLN_25 VGND sky130_fd_pr__nfet_01v8 w=0.42 l=0.17
XB18_26 VGND WL_18 BLN_26 VGND sky130_fd_pr__nfet_01v8 w=0.42 l=0.17
XB18_27 VGND WL_18 BLP_27 VGND sky130_fd_pr__nfet_01v8 w=0.42 l=0.17
XB18_28 VGND WL_18 nc_18_28 VGND sky130_fd_pr__nfet_01v8 w=0.42 l=0.17
XB18_29 VGND WL_18 nc_18_29 VGND sky130_fd_pr__nfet_01v8 w=0.42 l=0.17
XB18_30 VGND WL_18 BLP_30 VGND sky130_fd_pr__nfet_01v8 w=0.42 l=0.17
XB18_31 VGND WL_18 nc_18_31 VGND sky130_fd_pr__nfet_01v8 w=0.42 l=0.17
XB19_0 VGND WL_19 BLP_0 VGND sky130_fd_pr__nfet_01v8 w=0.42 l=0.17
XB19_1 VGND WL_19 BLN_1 VGND sky130_fd_pr__nfet_01v8 w=0.42 l=0.17
XB19_2 VGND WL_19 BLP_2 VGND sky130_fd_pr__nfet_01v8 w=0.42 l=0.17
XB19_3 VGND WL_19 BLP_3 VGND sky130_fd_pr__nfet_01v8 w=0.42 l=0.17
XB19_4 VGND WL_19 BLN_4 VGND sky130_fd_pr__nfet_01v8 w=0.42 l=0.17
XB19_5 VGND WL_19 nc_19_5 VGND sky130_fd_pr__nfet_01v8 w=0.42 l=0.17
XB19_6 VGND WL_19 BLN_6 VGND sky130_fd_pr__nfet_01v8 w=0.42 l=0.17
XB19_7 VGND WL_19 nc_19_7 VGND sky130_fd_pr__nfet_01v8 w=0.42 l=0.17
XB19_8 VGND WL_19 BLN_8 VGND sky130_fd_pr__nfet_01v8 w=0.42 l=0.17
XB19_9 VGND WL_19 BLN_9 VGND sky130_fd_pr__nfet_01v8 w=0.42 l=0.17
XB19_10 VGND WL_19 BLN_10 VGND sky130_fd_pr__nfet_01v8 w=0.42 l=0.17
XB19_11 VGND WL_19 BLN_11 VGND sky130_fd_pr__nfet_01v8 w=0.42 l=0.17
XB19_12 VGND WL_19 BLP_12 VGND sky130_fd_pr__nfet_01v8 w=0.42 l=0.17
XB19_13 VGND WL_19 nc_19_13 VGND sky130_fd_pr__nfet_01v8 w=0.42 l=0.17
XB19_14 VGND WL_19 nc_19_14 VGND sky130_fd_pr__nfet_01v8 w=0.42 l=0.17
XB19_15 VGND WL_19 nc_19_15 VGND sky130_fd_pr__nfet_01v8 w=0.42 l=0.17
XB19_16 VGND WL_19 BLN_16 VGND sky130_fd_pr__nfet_01v8 w=0.42 l=0.17
XB19_17 VGND WL_19 nc_19_17 VGND sky130_fd_pr__nfet_01v8 w=0.42 l=0.17
XB19_18 VGND WL_19 nc_19_18 VGND sky130_fd_pr__nfet_01v8 w=0.42 l=0.17
XB19_19 VGND WL_19 nc_19_19 VGND sky130_fd_pr__nfet_01v8 w=0.42 l=0.17
XB19_20 VGND WL_19 nc_19_20 VGND sky130_fd_pr__nfet_01v8 w=0.42 l=0.17
XB19_21 VGND WL_19 nc_19_21 VGND sky130_fd_pr__nfet_01v8 w=0.42 l=0.17
XB19_22 VGND WL_19 BLN_22 VGND sky130_fd_pr__nfet_01v8 w=0.42 l=0.17
XB19_23 VGND WL_19 BLP_23 VGND sky130_fd_pr__nfet_01v8 w=0.42 l=0.17
XB19_24 VGND WL_19 nc_19_24 VGND sky130_fd_pr__nfet_01v8 w=0.42 l=0.17
XB19_25 VGND WL_19 nc_19_25 VGND sky130_fd_pr__nfet_01v8 w=0.42 l=0.17
XB19_26 VGND WL_19 BLP_26 VGND sky130_fd_pr__nfet_01v8 w=0.42 l=0.17
XB19_27 VGND WL_19 BLP_27 VGND sky130_fd_pr__nfet_01v8 w=0.42 l=0.17
XB19_28 VGND WL_19 BLP_28 VGND sky130_fd_pr__nfet_01v8 w=0.42 l=0.17
XB19_29 VGND WL_19 nc_19_29 VGND sky130_fd_pr__nfet_01v8 w=0.42 l=0.17
XB19_30 VGND WL_19 nc_19_30 VGND sky130_fd_pr__nfet_01v8 w=0.42 l=0.17
XB19_31 VGND WL_19 nc_19_31 VGND sky130_fd_pr__nfet_01v8 w=0.42 l=0.17
XB20_0 VGND WL_20 BLN_0 VGND sky130_fd_pr__nfet_01v8 w=0.42 l=0.17
XB20_1 VGND WL_20 nc_20_1 VGND sky130_fd_pr__nfet_01v8 w=0.42 l=0.17
XB20_2 VGND WL_20 BLN_2 VGND sky130_fd_pr__nfet_01v8 w=0.42 l=0.17
XB20_3 VGND WL_20 BLP_3 VGND sky130_fd_pr__nfet_01v8 w=0.42 l=0.17
XB20_4 VGND WL_20 BLN_4 VGND sky130_fd_pr__nfet_01v8 w=0.42 l=0.17
XB20_5 VGND WL_20 nc_20_5 VGND sky130_fd_pr__nfet_01v8 w=0.42 l=0.17
XB20_6 VGND WL_20 nc_20_6 VGND sky130_fd_pr__nfet_01v8 w=0.42 l=0.17
XB20_7 VGND WL_20 BLP_7 VGND sky130_fd_pr__nfet_01v8 w=0.42 l=0.17
XB20_8 VGND WL_20 nc_20_8 VGND sky130_fd_pr__nfet_01v8 w=0.42 l=0.17
XB20_9 VGND WL_20 BLN_9 VGND sky130_fd_pr__nfet_01v8 w=0.42 l=0.17
XB20_10 VGND WL_20 BLN_10 VGND sky130_fd_pr__nfet_01v8 w=0.42 l=0.17
XB20_11 VGND WL_20 nc_20_11 VGND sky130_fd_pr__nfet_01v8 w=0.42 l=0.17
XB20_12 VGND WL_20 BLN_12 VGND sky130_fd_pr__nfet_01v8 w=0.42 l=0.17
XB20_13 VGND WL_20 BLN_13 VGND sky130_fd_pr__nfet_01v8 w=0.42 l=0.17
XB20_14 VGND WL_20 BLP_14 VGND sky130_fd_pr__nfet_01v8 w=0.42 l=0.17
XB20_15 VGND WL_20 nc_20_15 VGND sky130_fd_pr__nfet_01v8 w=0.42 l=0.17
XB20_16 VGND WL_20 nc_20_16 VGND sky130_fd_pr__nfet_01v8 w=0.42 l=0.17
XB20_17 VGND WL_20 BLN_17 VGND sky130_fd_pr__nfet_01v8 w=0.42 l=0.17
XB20_18 VGND WL_20 nc_20_18 VGND sky130_fd_pr__nfet_01v8 w=0.42 l=0.17
XB20_19 VGND WL_20 BLP_19 VGND sky130_fd_pr__nfet_01v8 w=0.42 l=0.17
XB20_20 VGND WL_20 nc_20_20 VGND sky130_fd_pr__nfet_01v8 w=0.42 l=0.17
XB20_21 VGND WL_20 nc_20_21 VGND sky130_fd_pr__nfet_01v8 w=0.42 l=0.17
XB20_22 VGND WL_20 nc_20_22 VGND sky130_fd_pr__nfet_01v8 w=0.42 l=0.17
XB20_23 VGND WL_20 nc_20_23 VGND sky130_fd_pr__nfet_01v8 w=0.42 l=0.17
XB20_24 VGND WL_20 BLP_24 VGND sky130_fd_pr__nfet_01v8 w=0.42 l=0.17
XB20_25 VGND WL_20 nc_20_25 VGND sky130_fd_pr__nfet_01v8 w=0.42 l=0.17
XB20_26 VGND WL_20 nc_20_26 VGND sky130_fd_pr__nfet_01v8 w=0.42 l=0.17
XB20_27 VGND WL_20 BLN_27 VGND sky130_fd_pr__nfet_01v8 w=0.42 l=0.17
XB20_28 VGND WL_20 BLP_28 VGND sky130_fd_pr__nfet_01v8 w=0.42 l=0.17
XB20_29 VGND WL_20 nc_20_29 VGND sky130_fd_pr__nfet_01v8 w=0.42 l=0.17
XB20_30 VGND WL_20 BLN_30 VGND sky130_fd_pr__nfet_01v8 w=0.42 l=0.17
XB20_31 VGND WL_20 nc_20_31 VGND sky130_fd_pr__nfet_01v8 w=0.42 l=0.17
XB21_0 VGND WL_21 BLN_0 VGND sky130_fd_pr__nfet_01v8 w=0.42 l=0.17
XB21_1 VGND WL_21 BLN_1 VGND sky130_fd_pr__nfet_01v8 w=0.42 l=0.17
XB21_2 VGND WL_21 BLP_2 VGND sky130_fd_pr__nfet_01v8 w=0.42 l=0.17
XB21_3 VGND WL_21 BLN_3 VGND sky130_fd_pr__nfet_01v8 w=0.42 l=0.17
XB21_4 VGND WL_21 BLN_4 VGND sky130_fd_pr__nfet_01v8 w=0.42 l=0.17
XB21_5 VGND WL_21 nc_21_5 VGND sky130_fd_pr__nfet_01v8 w=0.42 l=0.17
XB21_6 VGND WL_21 nc_21_6 VGND sky130_fd_pr__nfet_01v8 w=0.42 l=0.17
XB21_7 VGND WL_21 nc_21_7 VGND sky130_fd_pr__nfet_01v8 w=0.42 l=0.17
XB21_8 VGND WL_21 BLN_8 VGND sky130_fd_pr__nfet_01v8 w=0.42 l=0.17
XB21_9 VGND WL_21 BLP_9 VGND sky130_fd_pr__nfet_01v8 w=0.42 l=0.17
XB21_10 VGND WL_21 nc_21_10 VGND sky130_fd_pr__nfet_01v8 w=0.42 l=0.17
XB21_11 VGND WL_21 BLP_11 VGND sky130_fd_pr__nfet_01v8 w=0.42 l=0.17
XB21_12 VGND WL_21 nc_21_12 VGND sky130_fd_pr__nfet_01v8 w=0.42 l=0.17
XB21_13 VGND WL_21 nc_21_13 VGND sky130_fd_pr__nfet_01v8 w=0.42 l=0.17
XB21_14 VGND WL_21 nc_21_14 VGND sky130_fd_pr__nfet_01v8 w=0.42 l=0.17
XB21_15 VGND WL_21 BLN_15 VGND sky130_fd_pr__nfet_01v8 w=0.42 l=0.17
XB21_16 VGND WL_21 BLP_16 VGND sky130_fd_pr__nfet_01v8 w=0.42 l=0.17
XB21_17 VGND WL_21 nc_21_17 VGND sky130_fd_pr__nfet_01v8 w=0.42 l=0.17
XB21_18 VGND WL_21 nc_21_18 VGND sky130_fd_pr__nfet_01v8 w=0.42 l=0.17
XB21_19 VGND WL_21 nc_21_19 VGND sky130_fd_pr__nfet_01v8 w=0.42 l=0.17
XB21_20 VGND WL_21 nc_21_20 VGND sky130_fd_pr__nfet_01v8 w=0.42 l=0.17
XB21_21 VGND WL_21 BLP_21 VGND sky130_fd_pr__nfet_01v8 w=0.42 l=0.17
XB21_22 VGND WL_21 BLN_22 VGND sky130_fd_pr__nfet_01v8 w=0.42 l=0.17
XB21_23 VGND WL_21 BLP_23 VGND sky130_fd_pr__nfet_01v8 w=0.42 l=0.17
XB21_24 VGND WL_21 BLN_24 VGND sky130_fd_pr__nfet_01v8 w=0.42 l=0.17
XB21_25 VGND WL_21 BLP_25 VGND sky130_fd_pr__nfet_01v8 w=0.42 l=0.17
XB21_26 VGND WL_21 nc_21_26 VGND sky130_fd_pr__nfet_01v8 w=0.42 l=0.17
XB21_27 VGND WL_21 nc_21_27 VGND sky130_fd_pr__nfet_01v8 w=0.42 l=0.17
XB21_28 VGND WL_21 BLN_28 VGND sky130_fd_pr__nfet_01v8 w=0.42 l=0.17
XB21_29 VGND WL_21 BLN_29 VGND sky130_fd_pr__nfet_01v8 w=0.42 l=0.17
XB21_30 VGND WL_21 BLP_30 VGND sky130_fd_pr__nfet_01v8 w=0.42 l=0.17
XB21_31 VGND WL_21 BLN_31 VGND sky130_fd_pr__nfet_01v8 w=0.42 l=0.17
XB22_0 VGND WL_22 nc_22_0 VGND sky130_fd_pr__nfet_01v8 w=0.42 l=0.17
XB22_1 VGND WL_22 nc_22_1 VGND sky130_fd_pr__nfet_01v8 w=0.42 l=0.17
XB22_2 VGND WL_22 BLN_2 VGND sky130_fd_pr__nfet_01v8 w=0.42 l=0.17
XB22_3 VGND WL_22 nc_22_3 VGND sky130_fd_pr__nfet_01v8 w=0.42 l=0.17
XB22_4 VGND WL_22 BLN_4 VGND sky130_fd_pr__nfet_01v8 w=0.42 l=0.17
XB22_5 VGND WL_22 nc_22_5 VGND sky130_fd_pr__nfet_01v8 w=0.42 l=0.17
XB22_6 VGND WL_22 BLP_6 VGND sky130_fd_pr__nfet_01v8 w=0.42 l=0.17
XB22_7 VGND WL_22 BLN_7 VGND sky130_fd_pr__nfet_01v8 w=0.42 l=0.17
XB22_8 VGND WL_22 nc_22_8 VGND sky130_fd_pr__nfet_01v8 w=0.42 l=0.17
XB22_9 VGND WL_22 nc_22_9 VGND sky130_fd_pr__nfet_01v8 w=0.42 l=0.17
XB22_10 VGND WL_22 BLN_10 VGND sky130_fd_pr__nfet_01v8 w=0.42 l=0.17
XB22_11 VGND WL_22 nc_22_11 VGND sky130_fd_pr__nfet_01v8 w=0.42 l=0.17
XB22_12 VGND WL_22 nc_22_12 VGND sky130_fd_pr__nfet_01v8 w=0.42 l=0.17
XB22_13 VGND WL_22 nc_22_13 VGND sky130_fd_pr__nfet_01v8 w=0.42 l=0.17
XB22_14 VGND WL_22 BLP_14 VGND sky130_fd_pr__nfet_01v8 w=0.42 l=0.17
XB22_15 VGND WL_22 BLN_15 VGND sky130_fd_pr__nfet_01v8 w=0.42 l=0.17
XB22_16 VGND WL_22 nc_22_16 VGND sky130_fd_pr__nfet_01v8 w=0.42 l=0.17
XB22_17 VGND WL_22 nc_22_17 VGND sky130_fd_pr__nfet_01v8 w=0.42 l=0.17
XB22_18 VGND WL_22 nc_22_18 VGND sky130_fd_pr__nfet_01v8 w=0.42 l=0.17
XB22_19 VGND WL_22 BLN_19 VGND sky130_fd_pr__nfet_01v8 w=0.42 l=0.17
XB22_20 VGND WL_22 BLN_20 VGND sky130_fd_pr__nfet_01v8 w=0.42 l=0.17
XB22_21 VGND WL_22 nc_22_21 VGND sky130_fd_pr__nfet_01v8 w=0.42 l=0.17
XB22_22 VGND WL_22 nc_22_22 VGND sky130_fd_pr__nfet_01v8 w=0.42 l=0.17
XB22_23 VGND WL_22 BLP_23 VGND sky130_fd_pr__nfet_01v8 w=0.42 l=0.17
XB22_24 VGND WL_22 nc_22_24 VGND sky130_fd_pr__nfet_01v8 w=0.42 l=0.17
XB22_25 VGND WL_22 nc_22_25 VGND sky130_fd_pr__nfet_01v8 w=0.42 l=0.17
XB22_26 VGND WL_22 nc_22_26 VGND sky130_fd_pr__nfet_01v8 w=0.42 l=0.17
XB22_27 VGND WL_22 nc_22_27 VGND sky130_fd_pr__nfet_01v8 w=0.42 l=0.17
XB22_28 VGND WL_22 BLN_28 VGND sky130_fd_pr__nfet_01v8 w=0.42 l=0.17
XB22_29 VGND WL_22 nc_22_29 VGND sky130_fd_pr__nfet_01v8 w=0.42 l=0.17
XB22_30 VGND WL_22 BLP_30 VGND sky130_fd_pr__nfet_01v8 w=0.42 l=0.17
XB22_31 VGND WL_22 BLN_31 VGND sky130_fd_pr__nfet_01v8 w=0.42 l=0.17
XB23_0 VGND WL_23 nc_23_0 VGND sky130_fd_pr__nfet_01v8 w=0.42 l=0.17
XB23_1 VGND WL_23 nc_23_1 VGND sky130_fd_pr__nfet_01v8 w=0.42 l=0.17
XB23_2 VGND WL_23 nc_23_2 VGND sky130_fd_pr__nfet_01v8 w=0.42 l=0.17
XB23_3 VGND WL_23 BLP_3 VGND sky130_fd_pr__nfet_01v8 w=0.42 l=0.17
XB23_4 VGND WL_23 BLN_4 VGND sky130_fd_pr__nfet_01v8 w=0.42 l=0.17
XB23_5 VGND WL_23 nc_23_5 VGND sky130_fd_pr__nfet_01v8 w=0.42 l=0.17
XB23_6 VGND WL_23 BLN_6 VGND sky130_fd_pr__nfet_01v8 w=0.42 l=0.17
XB23_7 VGND WL_23 nc_23_7 VGND sky130_fd_pr__nfet_01v8 w=0.42 l=0.17
XB23_8 VGND WL_23 BLP_8 VGND sky130_fd_pr__nfet_01v8 w=0.42 l=0.17
XB23_9 VGND WL_23 nc_23_9 VGND sky130_fd_pr__nfet_01v8 w=0.42 l=0.17
XB23_10 VGND WL_23 nc_23_10 VGND sky130_fd_pr__nfet_01v8 w=0.42 l=0.17
XB23_11 VGND WL_23 nc_23_11 VGND sky130_fd_pr__nfet_01v8 w=0.42 l=0.17
XB23_12 VGND WL_23 BLP_12 VGND sky130_fd_pr__nfet_01v8 w=0.42 l=0.17
XB23_13 VGND WL_23 nc_23_13 VGND sky130_fd_pr__nfet_01v8 w=0.42 l=0.17
XB23_14 VGND WL_23 nc_23_14 VGND sky130_fd_pr__nfet_01v8 w=0.42 l=0.17
XB23_15 VGND WL_23 nc_23_15 VGND sky130_fd_pr__nfet_01v8 w=0.42 l=0.17
XB23_16 VGND WL_23 nc_23_16 VGND sky130_fd_pr__nfet_01v8 w=0.42 l=0.17
XB23_17 VGND WL_23 nc_23_17 VGND sky130_fd_pr__nfet_01v8 w=0.42 l=0.17
XB23_18 VGND WL_23 nc_23_18 VGND sky130_fd_pr__nfet_01v8 w=0.42 l=0.17
XB23_19 VGND WL_23 BLN_19 VGND sky130_fd_pr__nfet_01v8 w=0.42 l=0.17
XB23_20 VGND WL_23 nc_23_20 VGND sky130_fd_pr__nfet_01v8 w=0.42 l=0.17
XB23_21 VGND WL_23 nc_23_21 VGND sky130_fd_pr__nfet_01v8 w=0.42 l=0.17
XB23_22 VGND WL_23 BLP_22 VGND sky130_fd_pr__nfet_01v8 w=0.42 l=0.17
XB23_23 VGND WL_23 nc_23_23 VGND sky130_fd_pr__nfet_01v8 w=0.42 l=0.17
XB23_24 VGND WL_23 BLP_24 VGND sky130_fd_pr__nfet_01v8 w=0.42 l=0.17
XB23_25 VGND WL_23 nc_23_25 VGND sky130_fd_pr__nfet_01v8 w=0.42 l=0.17
XB23_26 VGND WL_23 BLP_26 VGND sky130_fd_pr__nfet_01v8 w=0.42 l=0.17
XB23_27 VGND WL_23 nc_23_27 VGND sky130_fd_pr__nfet_01v8 w=0.42 l=0.17
XB23_28 VGND WL_23 nc_23_28 VGND sky130_fd_pr__nfet_01v8 w=0.42 l=0.17
XB23_29 VGND WL_23 nc_23_29 VGND sky130_fd_pr__nfet_01v8 w=0.42 l=0.17
XB23_30 VGND WL_23 nc_23_30 VGND sky130_fd_pr__nfet_01v8 w=0.42 l=0.17
XB23_31 VGND WL_23 BLN_31 VGND sky130_fd_pr__nfet_01v8 w=0.42 l=0.17
XB24_0 VGND WL_24 BLP_0 VGND sky130_fd_pr__nfet_01v8 w=0.42 l=0.17
XB24_1 VGND WL_24 BLN_1 VGND sky130_fd_pr__nfet_01v8 w=0.42 l=0.17
XB24_2 VGND WL_24 nc_24_2 VGND sky130_fd_pr__nfet_01v8 w=0.42 l=0.17
XB24_3 VGND WL_24 BLP_3 VGND sky130_fd_pr__nfet_01v8 w=0.42 l=0.17
XB24_4 VGND WL_24 BLP_4 VGND sky130_fd_pr__nfet_01v8 w=0.42 l=0.17
XB24_5 VGND WL_24 BLN_5 VGND sky130_fd_pr__nfet_01v8 w=0.42 l=0.17
XB24_6 VGND WL_24 BLP_6 VGND sky130_fd_pr__nfet_01v8 w=0.42 l=0.17
XB24_7 VGND WL_24 nc_24_7 VGND sky130_fd_pr__nfet_01v8 w=0.42 l=0.17
XB24_8 VGND WL_24 nc_24_8 VGND sky130_fd_pr__nfet_01v8 w=0.42 l=0.17
XB24_9 VGND WL_24 nc_24_9 VGND sky130_fd_pr__nfet_01v8 w=0.42 l=0.17
XB24_10 VGND WL_24 BLP_10 VGND sky130_fd_pr__nfet_01v8 w=0.42 l=0.17
XB24_11 VGND WL_24 nc_24_11 VGND sky130_fd_pr__nfet_01v8 w=0.42 l=0.17
XB24_12 VGND WL_24 BLP_12 VGND sky130_fd_pr__nfet_01v8 w=0.42 l=0.17
XB24_13 VGND WL_24 nc_24_13 VGND sky130_fd_pr__nfet_01v8 w=0.42 l=0.17
XB24_14 VGND WL_24 nc_24_14 VGND sky130_fd_pr__nfet_01v8 w=0.42 l=0.17
XB24_15 VGND WL_24 BLP_15 VGND sky130_fd_pr__nfet_01v8 w=0.42 l=0.17
XB24_16 VGND WL_24 nc_24_16 VGND sky130_fd_pr__nfet_01v8 w=0.42 l=0.17
XB24_17 VGND WL_24 nc_24_17 VGND sky130_fd_pr__nfet_01v8 w=0.42 l=0.17
XB24_18 VGND WL_24 nc_24_18 VGND sky130_fd_pr__nfet_01v8 w=0.42 l=0.17
XB24_19 VGND WL_24 BLN_19 VGND sky130_fd_pr__nfet_01v8 w=0.42 l=0.17
XB24_20 VGND WL_24 nc_24_20 VGND sky130_fd_pr__nfet_01v8 w=0.42 l=0.17
XB24_21 VGND WL_24 nc_24_21 VGND sky130_fd_pr__nfet_01v8 w=0.42 l=0.17
XB24_22 VGND WL_24 nc_24_22 VGND sky130_fd_pr__nfet_01v8 w=0.42 l=0.17
XB24_23 VGND WL_24 BLP_23 VGND sky130_fd_pr__nfet_01v8 w=0.42 l=0.17
XB24_24 VGND WL_24 nc_24_24 VGND sky130_fd_pr__nfet_01v8 w=0.42 l=0.17
XB24_25 VGND WL_24 nc_24_25 VGND sky130_fd_pr__nfet_01v8 w=0.42 l=0.17
XB24_26 VGND WL_24 BLN_26 VGND sky130_fd_pr__nfet_01v8 w=0.42 l=0.17
XB24_27 VGND WL_24 nc_24_27 VGND sky130_fd_pr__nfet_01v8 w=0.42 l=0.17
XB24_28 VGND WL_24 nc_24_28 VGND sky130_fd_pr__nfet_01v8 w=0.42 l=0.17
XB24_29 VGND WL_24 nc_24_29 VGND sky130_fd_pr__nfet_01v8 w=0.42 l=0.17
XB24_30 VGND WL_24 nc_24_30 VGND sky130_fd_pr__nfet_01v8 w=0.42 l=0.17
XB24_31 VGND WL_24 BLP_31 VGND sky130_fd_pr__nfet_01v8 w=0.42 l=0.17
XB25_0 VGND WL_25 BLN_0 VGND sky130_fd_pr__nfet_01v8 w=0.42 l=0.17
XB25_1 VGND WL_25 BLN_1 VGND sky130_fd_pr__nfet_01v8 w=0.42 l=0.17
XB25_2 VGND WL_25 nc_25_2 VGND sky130_fd_pr__nfet_01v8 w=0.42 l=0.17
XB25_3 VGND WL_25 BLN_3 VGND sky130_fd_pr__nfet_01v8 w=0.42 l=0.17
XB25_4 VGND WL_25 BLN_4 VGND sky130_fd_pr__nfet_01v8 w=0.42 l=0.17
XB25_5 VGND WL_25 nc_25_5 VGND sky130_fd_pr__nfet_01v8 w=0.42 l=0.17
XB25_6 VGND WL_25 nc_25_6 VGND sky130_fd_pr__nfet_01v8 w=0.42 l=0.17
XB25_7 VGND WL_25 nc_25_7 VGND sky130_fd_pr__nfet_01v8 w=0.42 l=0.17
XB25_8 VGND WL_25 nc_25_8 VGND sky130_fd_pr__nfet_01v8 w=0.42 l=0.17
XB25_9 VGND WL_25 nc_25_9 VGND sky130_fd_pr__nfet_01v8 w=0.42 l=0.17
XB25_10 VGND WL_25 BLN_10 VGND sky130_fd_pr__nfet_01v8 w=0.42 l=0.17
XB25_11 VGND WL_25 nc_25_11 VGND sky130_fd_pr__nfet_01v8 w=0.42 l=0.17
XB25_12 VGND WL_25 BLP_12 VGND sky130_fd_pr__nfet_01v8 w=0.42 l=0.17
XB25_13 VGND WL_25 BLP_13 VGND sky130_fd_pr__nfet_01v8 w=0.42 l=0.17
XB25_14 VGND WL_25 nc_25_14 VGND sky130_fd_pr__nfet_01v8 w=0.42 l=0.17
XB25_15 VGND WL_25 nc_25_15 VGND sky130_fd_pr__nfet_01v8 w=0.42 l=0.17
XB25_16 VGND WL_25 nc_25_16 VGND sky130_fd_pr__nfet_01v8 w=0.42 l=0.17
XB25_17 VGND WL_25 nc_25_17 VGND sky130_fd_pr__nfet_01v8 w=0.42 l=0.17
XB25_18 VGND WL_25 nc_25_18 VGND sky130_fd_pr__nfet_01v8 w=0.42 l=0.17
XB25_19 VGND WL_25 nc_25_19 VGND sky130_fd_pr__nfet_01v8 w=0.42 l=0.17
XB25_20 VGND WL_25 nc_25_20 VGND sky130_fd_pr__nfet_01v8 w=0.42 l=0.17
XB25_21 VGND WL_25 BLN_21 VGND sky130_fd_pr__nfet_01v8 w=0.42 l=0.17
XB25_22 VGND WL_25 BLN_22 VGND sky130_fd_pr__nfet_01v8 w=0.42 l=0.17
XB25_23 VGND WL_25 BLP_23 VGND sky130_fd_pr__nfet_01v8 w=0.42 l=0.17
XB25_24 VGND WL_25 BLN_24 VGND sky130_fd_pr__nfet_01v8 w=0.42 l=0.17
XB25_25 VGND WL_25 nc_25_25 VGND sky130_fd_pr__nfet_01v8 w=0.42 l=0.17
XB25_26 VGND WL_25 BLN_26 VGND sky130_fd_pr__nfet_01v8 w=0.42 l=0.17
XB25_27 VGND WL_25 nc_25_27 VGND sky130_fd_pr__nfet_01v8 w=0.42 l=0.17
XB25_28 VGND WL_25 nc_25_28 VGND sky130_fd_pr__nfet_01v8 w=0.42 l=0.17
XB25_29 VGND WL_25 BLN_29 VGND sky130_fd_pr__nfet_01v8 w=0.42 l=0.17
XB25_30 VGND WL_25 nc_25_30 VGND sky130_fd_pr__nfet_01v8 w=0.42 l=0.17
XB25_31 VGND WL_25 BLP_31 VGND sky130_fd_pr__nfet_01v8 w=0.42 l=0.17
XB26_0 VGND WL_26 BLP_0 VGND sky130_fd_pr__nfet_01v8 w=0.42 l=0.17
XB26_1 VGND WL_26 nc_26_1 VGND sky130_fd_pr__nfet_01v8 w=0.42 l=0.17
XB26_2 VGND WL_26 BLP_2 VGND sky130_fd_pr__nfet_01v8 w=0.42 l=0.17
XB26_3 VGND WL_26 BLN_3 VGND sky130_fd_pr__nfet_01v8 w=0.42 l=0.17
XB26_4 VGND WL_26 nc_26_4 VGND sky130_fd_pr__nfet_01v8 w=0.42 l=0.17
XB26_5 VGND WL_26 nc_26_5 VGND sky130_fd_pr__nfet_01v8 w=0.42 l=0.17
XB26_6 VGND WL_26 nc_26_6 VGND sky130_fd_pr__nfet_01v8 w=0.42 l=0.17
XB26_7 VGND WL_26 BLP_7 VGND sky130_fd_pr__nfet_01v8 w=0.42 l=0.17
XB26_8 VGND WL_26 BLP_8 VGND sky130_fd_pr__nfet_01v8 w=0.42 l=0.17
XB26_9 VGND WL_26 nc_26_9 VGND sky130_fd_pr__nfet_01v8 w=0.42 l=0.17
XB26_10 VGND WL_26 BLP_10 VGND sky130_fd_pr__nfet_01v8 w=0.42 l=0.17
XB26_11 VGND WL_26 nc_26_11 VGND sky130_fd_pr__nfet_01v8 w=0.42 l=0.17
XB26_12 VGND WL_26 nc_26_12 VGND sky130_fd_pr__nfet_01v8 w=0.42 l=0.17
XB26_13 VGND WL_26 nc_26_13 VGND sky130_fd_pr__nfet_01v8 w=0.42 l=0.17
XB26_14 VGND WL_26 BLN_14 VGND sky130_fd_pr__nfet_01v8 w=0.42 l=0.17
XB26_15 VGND WL_26 BLN_15 VGND sky130_fd_pr__nfet_01v8 w=0.42 l=0.17
XB26_16 VGND WL_26 BLP_16 VGND sky130_fd_pr__nfet_01v8 w=0.42 l=0.17
XB26_17 VGND WL_26 nc_26_17 VGND sky130_fd_pr__nfet_01v8 w=0.42 l=0.17
XB26_18 VGND WL_26 nc_26_18 VGND sky130_fd_pr__nfet_01v8 w=0.42 l=0.17
XB26_19 VGND WL_26 nc_26_19 VGND sky130_fd_pr__nfet_01v8 w=0.42 l=0.17
XB26_20 VGND WL_26 nc_26_20 VGND sky130_fd_pr__nfet_01v8 w=0.42 l=0.17
XB26_21 VGND WL_26 nc_26_21 VGND sky130_fd_pr__nfet_01v8 w=0.42 l=0.17
XB26_22 VGND WL_26 BLP_22 VGND sky130_fd_pr__nfet_01v8 w=0.42 l=0.17
XB26_23 VGND WL_26 nc_26_23 VGND sky130_fd_pr__nfet_01v8 w=0.42 l=0.17
XB26_24 VGND WL_26 BLP_24 VGND sky130_fd_pr__nfet_01v8 w=0.42 l=0.17
XB26_25 VGND WL_26 nc_26_25 VGND sky130_fd_pr__nfet_01v8 w=0.42 l=0.17
XB26_26 VGND WL_26 BLP_26 VGND sky130_fd_pr__nfet_01v8 w=0.42 l=0.17
XB26_27 VGND WL_26 nc_26_27 VGND sky130_fd_pr__nfet_01v8 w=0.42 l=0.17
XB26_28 VGND WL_26 nc_26_28 VGND sky130_fd_pr__nfet_01v8 w=0.42 l=0.17
XB26_29 VGND WL_26 nc_26_29 VGND sky130_fd_pr__nfet_01v8 w=0.42 l=0.17
XB26_30 VGND WL_26 BLP_30 VGND sky130_fd_pr__nfet_01v8 w=0.42 l=0.17
XB26_31 VGND WL_26 BLP_31 VGND sky130_fd_pr__nfet_01v8 w=0.42 l=0.17
XB27_0 VGND WL_27 BLN_0 VGND sky130_fd_pr__nfet_01v8 w=0.42 l=0.17
XB27_1 VGND WL_27 BLN_1 VGND sky130_fd_pr__nfet_01v8 w=0.42 l=0.17
XB27_2 VGND WL_27 BLN_2 VGND sky130_fd_pr__nfet_01v8 w=0.42 l=0.17
XB27_3 VGND WL_27 nc_27_3 VGND sky130_fd_pr__nfet_01v8 w=0.42 l=0.17
XB27_4 VGND WL_27 BLP_4 VGND sky130_fd_pr__nfet_01v8 w=0.42 l=0.17
XB27_5 VGND WL_27 BLN_5 VGND sky130_fd_pr__nfet_01v8 w=0.42 l=0.17
XB27_6 VGND WL_27 nc_27_6 VGND sky130_fd_pr__nfet_01v8 w=0.42 l=0.17
XB27_7 VGND WL_27 nc_27_7 VGND sky130_fd_pr__nfet_01v8 w=0.42 l=0.17
XB27_8 VGND WL_27 BLN_8 VGND sky130_fd_pr__nfet_01v8 w=0.42 l=0.17
XB27_9 VGND WL_27 nc_27_9 VGND sky130_fd_pr__nfet_01v8 w=0.42 l=0.17
XB27_10 VGND WL_27 BLP_10 VGND sky130_fd_pr__nfet_01v8 w=0.42 l=0.17
XB27_11 VGND WL_27 BLP_11 VGND sky130_fd_pr__nfet_01v8 w=0.42 l=0.17
XB27_12 VGND WL_27 BLN_12 VGND sky130_fd_pr__nfet_01v8 w=0.42 l=0.17
XB27_13 VGND WL_27 BLP_13 VGND sky130_fd_pr__nfet_01v8 w=0.42 l=0.17
XB27_14 VGND WL_27 nc_27_14 VGND sky130_fd_pr__nfet_01v8 w=0.42 l=0.17
XB27_15 VGND WL_27 BLN_15 VGND sky130_fd_pr__nfet_01v8 w=0.42 l=0.17
XB27_16 VGND WL_27 nc_27_16 VGND sky130_fd_pr__nfet_01v8 w=0.42 l=0.17
XB27_17 VGND WL_27 BLN_17 VGND sky130_fd_pr__nfet_01v8 w=0.42 l=0.17
XB27_18 VGND WL_27 BLN_18 VGND sky130_fd_pr__nfet_01v8 w=0.42 l=0.17
XB27_19 VGND WL_27 nc_27_19 VGND sky130_fd_pr__nfet_01v8 w=0.42 l=0.17
XB27_20 VGND WL_27 nc_27_20 VGND sky130_fd_pr__nfet_01v8 w=0.42 l=0.17
XB27_21 VGND WL_27 BLP_21 VGND sky130_fd_pr__nfet_01v8 w=0.42 l=0.17
XB27_22 VGND WL_27 nc_27_22 VGND sky130_fd_pr__nfet_01v8 w=0.42 l=0.17
XB27_23 VGND WL_27 nc_27_23 VGND sky130_fd_pr__nfet_01v8 w=0.42 l=0.17
XB27_24 VGND WL_27 BLP_24 VGND sky130_fd_pr__nfet_01v8 w=0.42 l=0.17
XB27_25 VGND WL_27 nc_27_25 VGND sky130_fd_pr__nfet_01v8 w=0.42 l=0.17
XB27_26 VGND WL_27 BLN_26 VGND sky130_fd_pr__nfet_01v8 w=0.42 l=0.17
XB27_27 VGND WL_27 nc_27_27 VGND sky130_fd_pr__nfet_01v8 w=0.42 l=0.17
XB27_28 VGND WL_27 nc_27_28 VGND sky130_fd_pr__nfet_01v8 w=0.42 l=0.17
XB27_29 VGND WL_27 BLP_29 VGND sky130_fd_pr__nfet_01v8 w=0.42 l=0.17
XB27_30 VGND WL_27 nc_27_30 VGND sky130_fd_pr__nfet_01v8 w=0.42 l=0.17
XB27_31 VGND WL_27 BLN_31 VGND sky130_fd_pr__nfet_01v8 w=0.42 l=0.17
XB28_0 VGND WL_28 nc_28_0 VGND sky130_fd_pr__nfet_01v8 w=0.42 l=0.17
XB28_1 VGND WL_28 BLN_1 VGND sky130_fd_pr__nfet_01v8 w=0.42 l=0.17
XB28_2 VGND WL_28 BLP_2 VGND sky130_fd_pr__nfet_01v8 w=0.42 l=0.17
XB28_3 VGND WL_28 BLN_3 VGND sky130_fd_pr__nfet_01v8 w=0.42 l=0.17
XB28_4 VGND WL_28 nc_28_4 VGND sky130_fd_pr__nfet_01v8 w=0.42 l=0.17
XB28_5 VGND WL_28 BLP_5 VGND sky130_fd_pr__nfet_01v8 w=0.42 l=0.17
XB28_6 VGND WL_28 BLN_6 VGND sky130_fd_pr__nfet_01v8 w=0.42 l=0.17
XB28_7 VGND WL_28 nc_28_7 VGND sky130_fd_pr__nfet_01v8 w=0.42 l=0.17
XB28_8 VGND WL_28 BLP_8 VGND sky130_fd_pr__nfet_01v8 w=0.42 l=0.17
XB28_9 VGND WL_28 nc_28_9 VGND sky130_fd_pr__nfet_01v8 w=0.42 l=0.17
XB28_10 VGND WL_28 BLP_10 VGND sky130_fd_pr__nfet_01v8 w=0.42 l=0.17
XB28_11 VGND WL_28 nc_28_11 VGND sky130_fd_pr__nfet_01v8 w=0.42 l=0.17
XB28_12 VGND WL_28 BLP_12 VGND sky130_fd_pr__nfet_01v8 w=0.42 l=0.17
XB28_13 VGND WL_28 nc_28_13 VGND sky130_fd_pr__nfet_01v8 w=0.42 l=0.17
XB28_14 VGND WL_28 nc_28_14 VGND sky130_fd_pr__nfet_01v8 w=0.42 l=0.17
XB28_15 VGND WL_28 nc_28_15 VGND sky130_fd_pr__nfet_01v8 w=0.42 l=0.17
XB28_16 VGND WL_28 BLP_16 VGND sky130_fd_pr__nfet_01v8 w=0.42 l=0.17
XB28_17 VGND WL_28 BLP_17 VGND sky130_fd_pr__nfet_01v8 w=0.42 l=0.17
XB28_18 VGND WL_28 nc_28_18 VGND sky130_fd_pr__nfet_01v8 w=0.42 l=0.17
XB28_19 VGND WL_28 nc_28_19 VGND sky130_fd_pr__nfet_01v8 w=0.42 l=0.17
XB28_20 VGND WL_28 BLP_20 VGND sky130_fd_pr__nfet_01v8 w=0.42 l=0.17
XB28_21 VGND WL_28 BLP_21 VGND sky130_fd_pr__nfet_01v8 w=0.42 l=0.17
XB28_22 VGND WL_28 BLP_22 VGND sky130_fd_pr__nfet_01v8 w=0.42 l=0.17
XB28_23 VGND WL_28 nc_28_23 VGND sky130_fd_pr__nfet_01v8 w=0.42 l=0.17
XB28_24 VGND WL_28 BLN_24 VGND sky130_fd_pr__nfet_01v8 w=0.42 l=0.17
XB28_25 VGND WL_28 BLN_25 VGND sky130_fd_pr__nfet_01v8 w=0.42 l=0.17
XB28_26 VGND WL_28 nc_28_26 VGND sky130_fd_pr__nfet_01v8 w=0.42 l=0.17
XB28_27 VGND WL_28 BLP_27 VGND sky130_fd_pr__nfet_01v8 w=0.42 l=0.17
XB28_28 VGND WL_28 nc_28_28 VGND sky130_fd_pr__nfet_01v8 w=0.42 l=0.17
XB28_29 VGND WL_28 BLP_29 VGND sky130_fd_pr__nfet_01v8 w=0.42 l=0.17
XB28_30 VGND WL_28 BLP_30 VGND sky130_fd_pr__nfet_01v8 w=0.42 l=0.17
XB28_31 VGND WL_28 BLP_31 VGND sky130_fd_pr__nfet_01v8 w=0.42 l=0.17
XB29_0 VGND WL_29 BLP_0 VGND sky130_fd_pr__nfet_01v8 w=0.42 l=0.17
XB29_1 VGND WL_29 BLN_1 VGND sky130_fd_pr__nfet_01v8 w=0.42 l=0.17
XB29_2 VGND WL_29 nc_29_2 VGND sky130_fd_pr__nfet_01v8 w=0.42 l=0.17
XB29_3 VGND WL_29 nc_29_3 VGND sky130_fd_pr__nfet_01v8 w=0.42 l=0.17
XB29_4 VGND WL_29 nc_29_4 VGND sky130_fd_pr__nfet_01v8 w=0.42 l=0.17
XB29_5 VGND WL_29 BLP_5 VGND sky130_fd_pr__nfet_01v8 w=0.42 l=0.17
XB29_6 VGND WL_29 nc_29_6 VGND sky130_fd_pr__nfet_01v8 w=0.42 l=0.17
XB29_7 VGND WL_29 nc_29_7 VGND sky130_fd_pr__nfet_01v8 w=0.42 l=0.17
XB29_8 VGND WL_29 nc_29_8 VGND sky130_fd_pr__nfet_01v8 w=0.42 l=0.17
XB29_9 VGND WL_29 nc_29_9 VGND sky130_fd_pr__nfet_01v8 w=0.42 l=0.17
XB29_10 VGND WL_29 nc_29_10 VGND sky130_fd_pr__nfet_01v8 w=0.42 l=0.17
XB29_11 VGND WL_29 BLP_11 VGND sky130_fd_pr__nfet_01v8 w=0.42 l=0.17
XB29_12 VGND WL_29 BLN_12 VGND sky130_fd_pr__nfet_01v8 w=0.42 l=0.17
XB29_13 VGND WL_29 nc_29_13 VGND sky130_fd_pr__nfet_01v8 w=0.42 l=0.17
XB29_14 VGND WL_29 BLP_14 VGND sky130_fd_pr__nfet_01v8 w=0.42 l=0.17
XB29_15 VGND WL_29 BLP_15 VGND sky130_fd_pr__nfet_01v8 w=0.42 l=0.17
XB29_16 VGND WL_29 nc_29_16 VGND sky130_fd_pr__nfet_01v8 w=0.42 l=0.17
XB29_17 VGND WL_29 BLN_17 VGND sky130_fd_pr__nfet_01v8 w=0.42 l=0.17
XB29_18 VGND WL_29 nc_29_18 VGND sky130_fd_pr__nfet_01v8 w=0.42 l=0.17
XB29_19 VGND WL_29 BLN_19 VGND sky130_fd_pr__nfet_01v8 w=0.42 l=0.17
XB29_20 VGND WL_29 nc_29_20 VGND sky130_fd_pr__nfet_01v8 w=0.42 l=0.17
XB29_21 VGND WL_29 nc_29_21 VGND sky130_fd_pr__nfet_01v8 w=0.42 l=0.17
XB29_22 VGND WL_29 BLN_22 VGND sky130_fd_pr__nfet_01v8 w=0.42 l=0.17
XB29_23 VGND WL_29 BLN_23 VGND sky130_fd_pr__nfet_01v8 w=0.42 l=0.17
XB29_24 VGND WL_29 nc_29_24 VGND sky130_fd_pr__nfet_01v8 w=0.42 l=0.17
XB29_25 VGND WL_29 BLN_25 VGND sky130_fd_pr__nfet_01v8 w=0.42 l=0.17
XB29_26 VGND WL_29 nc_29_26 VGND sky130_fd_pr__nfet_01v8 w=0.42 l=0.17
XB29_27 VGND WL_29 nc_29_27 VGND sky130_fd_pr__nfet_01v8 w=0.42 l=0.17
XB29_28 VGND WL_29 BLP_28 VGND sky130_fd_pr__nfet_01v8 w=0.42 l=0.17
XB29_29 VGND WL_29 BLP_29 VGND sky130_fd_pr__nfet_01v8 w=0.42 l=0.17
XB29_30 VGND WL_29 nc_29_30 VGND sky130_fd_pr__nfet_01v8 w=0.42 l=0.17
XB29_31 VGND WL_29 nc_29_31 VGND sky130_fd_pr__nfet_01v8 w=0.42 l=0.17
XB30_0 VGND WL_30 nc_30_0 VGND sky130_fd_pr__nfet_01v8 w=0.42 l=0.17
XB30_1 VGND WL_30 nc_30_1 VGND sky130_fd_pr__nfet_01v8 w=0.42 l=0.17
XB30_2 VGND WL_30 BLP_2 VGND sky130_fd_pr__nfet_01v8 w=0.42 l=0.17
XB30_3 VGND WL_30 nc_30_3 VGND sky130_fd_pr__nfet_01v8 w=0.42 l=0.17
XB30_4 VGND WL_30 BLP_4 VGND sky130_fd_pr__nfet_01v8 w=0.42 l=0.17
XB30_5 VGND WL_30 nc_30_5 VGND sky130_fd_pr__nfet_01v8 w=0.42 l=0.17
XB30_6 VGND WL_30 nc_30_6 VGND sky130_fd_pr__nfet_01v8 w=0.42 l=0.17
XB30_7 VGND WL_30 BLP_7 VGND sky130_fd_pr__nfet_01v8 w=0.42 l=0.17
XB30_8 VGND WL_30 nc_30_8 VGND sky130_fd_pr__nfet_01v8 w=0.42 l=0.17
XB30_9 VGND WL_30 nc_30_9 VGND sky130_fd_pr__nfet_01v8 w=0.42 l=0.17
XB30_10 VGND WL_30 nc_30_10 VGND sky130_fd_pr__nfet_01v8 w=0.42 l=0.17
XB30_11 VGND WL_30 BLP_11 VGND sky130_fd_pr__nfet_01v8 w=0.42 l=0.17
XB30_12 VGND WL_30 BLP_12 VGND sky130_fd_pr__nfet_01v8 w=0.42 l=0.17
XB30_13 VGND WL_30 BLN_13 VGND sky130_fd_pr__nfet_01v8 w=0.42 l=0.17
XB30_14 VGND WL_30 nc_30_14 VGND sky130_fd_pr__nfet_01v8 w=0.42 l=0.17
XB30_15 VGND WL_30 BLN_15 VGND sky130_fd_pr__nfet_01v8 w=0.42 l=0.17
XB30_16 VGND WL_30 nc_30_16 VGND sky130_fd_pr__nfet_01v8 w=0.42 l=0.17
XB30_17 VGND WL_30 BLN_17 VGND sky130_fd_pr__nfet_01v8 w=0.42 l=0.17
XB30_18 VGND WL_30 BLP_18 VGND sky130_fd_pr__nfet_01v8 w=0.42 l=0.17
XB30_19 VGND WL_30 BLP_19 VGND sky130_fd_pr__nfet_01v8 w=0.42 l=0.17
XB30_20 VGND WL_30 BLP_20 VGND sky130_fd_pr__nfet_01v8 w=0.42 l=0.17
XB30_21 VGND WL_30 nc_30_21 VGND sky130_fd_pr__nfet_01v8 w=0.42 l=0.17
XB30_22 VGND WL_30 BLN_22 VGND sky130_fd_pr__nfet_01v8 w=0.42 l=0.17
XB30_23 VGND WL_30 nc_30_23 VGND sky130_fd_pr__nfet_01v8 w=0.42 l=0.17
XB30_24 VGND WL_30 BLN_24 VGND sky130_fd_pr__nfet_01v8 w=0.42 l=0.17
XB30_25 VGND WL_30 nc_30_25 VGND sky130_fd_pr__nfet_01v8 w=0.42 l=0.17
XB30_26 VGND WL_30 BLP_26 VGND sky130_fd_pr__nfet_01v8 w=0.42 l=0.17
XB30_27 VGND WL_30 BLN_27 VGND sky130_fd_pr__nfet_01v8 w=0.42 l=0.17
XB30_28 VGND WL_30 BLN_28 VGND sky130_fd_pr__nfet_01v8 w=0.42 l=0.17
XB30_29 VGND WL_30 BLN_29 VGND sky130_fd_pr__nfet_01v8 w=0.42 l=0.17
XB30_30 VGND WL_30 nc_30_30 VGND sky130_fd_pr__nfet_01v8 w=0.42 l=0.17
XB30_31 VGND WL_30 BLP_31 VGND sky130_fd_pr__nfet_01v8 w=0.42 l=0.17
XB31_0 VGND WL_31 BLN_0 VGND sky130_fd_pr__nfet_01v8 w=0.42 l=0.17
XB31_1 VGND WL_31 BLP_1 VGND sky130_fd_pr__nfet_01v8 w=0.42 l=0.17
XB31_2 VGND WL_31 BLP_2 VGND sky130_fd_pr__nfet_01v8 w=0.42 l=0.17
XB31_3 VGND WL_31 nc_31_3 VGND sky130_fd_pr__nfet_01v8 w=0.42 l=0.17
XB31_4 VGND WL_31 nc_31_4 VGND sky130_fd_pr__nfet_01v8 w=0.42 l=0.17
XB31_5 VGND WL_31 BLP_5 VGND sky130_fd_pr__nfet_01v8 w=0.42 l=0.17
XB31_6 VGND WL_31 BLN_6 VGND sky130_fd_pr__nfet_01v8 w=0.42 l=0.17
XB31_7 VGND WL_31 BLN_7 VGND sky130_fd_pr__nfet_01v8 w=0.42 l=0.17
XB31_8 VGND WL_31 nc_31_8 VGND sky130_fd_pr__nfet_01v8 w=0.42 l=0.17
XB31_9 VGND WL_31 BLP_9 VGND sky130_fd_pr__nfet_01v8 w=0.42 l=0.17
XB31_10 VGND WL_31 nc_31_10 VGND sky130_fd_pr__nfet_01v8 w=0.42 l=0.17
XB31_11 VGND WL_31 BLP_11 VGND sky130_fd_pr__nfet_01v8 w=0.42 l=0.17
XB31_12 VGND WL_31 BLP_12 VGND sky130_fd_pr__nfet_01v8 w=0.42 l=0.17
XB31_13 VGND WL_31 BLN_13 VGND sky130_fd_pr__nfet_01v8 w=0.42 l=0.17
XB31_14 VGND WL_31 nc_31_14 VGND sky130_fd_pr__nfet_01v8 w=0.42 l=0.17
XB31_15 VGND WL_31 nc_31_15 VGND sky130_fd_pr__nfet_01v8 w=0.42 l=0.17
XB31_16 VGND WL_31 BLN_16 VGND sky130_fd_pr__nfet_01v8 w=0.42 l=0.17
XB31_17 VGND WL_31 nc_31_17 VGND sky130_fd_pr__nfet_01v8 w=0.42 l=0.17
XB31_18 VGND WL_31 nc_31_18 VGND sky130_fd_pr__nfet_01v8 w=0.42 l=0.17
XB31_19 VGND WL_31 nc_31_19 VGND sky130_fd_pr__nfet_01v8 w=0.42 l=0.17
XB31_20 VGND WL_31 nc_31_20 VGND sky130_fd_pr__nfet_01v8 w=0.42 l=0.17
XB31_21 VGND WL_31 BLN_21 VGND sky130_fd_pr__nfet_01v8 w=0.42 l=0.17
XB31_22 VGND WL_31 BLP_22 VGND sky130_fd_pr__nfet_01v8 w=0.42 l=0.17
XB31_23 VGND WL_31 BLP_23 VGND sky130_fd_pr__nfet_01v8 w=0.42 l=0.17
XB31_24 VGND WL_31 BLN_24 VGND sky130_fd_pr__nfet_01v8 w=0.42 l=0.17
XB31_25 VGND WL_31 nc_31_25 VGND sky130_fd_pr__nfet_01v8 w=0.42 l=0.17
XB31_26 VGND WL_31 nc_31_26 VGND sky130_fd_pr__nfet_01v8 w=0.42 l=0.17
XB31_27 VGND WL_31 nc_31_27 VGND sky130_fd_pr__nfet_01v8 w=0.42 l=0.17
XB31_28 VGND WL_31 BLN_28 VGND sky130_fd_pr__nfet_01v8 w=0.42 l=0.17
XB31_29 VGND WL_31 nc_31_29 VGND sky130_fd_pr__nfet_01v8 w=0.42 l=0.17
XB31_30 VGND WL_31 BLP_30 VGND sky130_fd_pr__nfet_01v8 w=0.42 l=0.17
XB31_31 VGND WL_31 nc_31_31 VGND sky130_fd_pr__nfet_01v8 w=0.42 l=0.17
XB32_0 VGND WL_32 nc_32_0 VGND sky130_fd_pr__nfet_01v8 w=0.42 l=0.17
XB32_1 VGND WL_32 nc_32_1 VGND sky130_fd_pr__nfet_01v8 w=0.42 l=0.17
XB32_2 VGND WL_32 nc_32_2 VGND sky130_fd_pr__nfet_01v8 w=0.42 l=0.17
XB32_3 VGND WL_32 BLN_3 VGND sky130_fd_pr__nfet_01v8 w=0.42 l=0.17
XB32_4 VGND WL_32 BLP_4 VGND sky130_fd_pr__nfet_01v8 w=0.42 l=0.17
XB32_5 VGND WL_32 BLP_5 VGND sky130_fd_pr__nfet_01v8 w=0.42 l=0.17
XB32_6 VGND WL_32 BLN_6 VGND sky130_fd_pr__nfet_01v8 w=0.42 l=0.17
XB32_7 VGND WL_32 BLN_7 VGND sky130_fd_pr__nfet_01v8 w=0.42 l=0.17
XB32_8 VGND WL_32 nc_32_8 VGND sky130_fd_pr__nfet_01v8 w=0.42 l=0.17
XB32_9 VGND WL_32 nc_32_9 VGND sky130_fd_pr__nfet_01v8 w=0.42 l=0.17
XB32_10 VGND WL_32 BLN_10 VGND sky130_fd_pr__nfet_01v8 w=0.42 l=0.17
XB32_11 VGND WL_32 nc_32_11 VGND sky130_fd_pr__nfet_01v8 w=0.42 l=0.17
XB32_12 VGND WL_32 nc_32_12 VGND sky130_fd_pr__nfet_01v8 w=0.42 l=0.17
XB32_13 VGND WL_32 BLN_13 VGND sky130_fd_pr__nfet_01v8 w=0.42 l=0.17
XB32_14 VGND WL_32 nc_32_14 VGND sky130_fd_pr__nfet_01v8 w=0.42 l=0.17
XB32_15 VGND WL_32 nc_32_15 VGND sky130_fd_pr__nfet_01v8 w=0.42 l=0.17
XB32_16 VGND WL_32 nc_32_16 VGND sky130_fd_pr__nfet_01v8 w=0.42 l=0.17
XB32_17 VGND WL_32 nc_32_17 VGND sky130_fd_pr__nfet_01v8 w=0.42 l=0.17
XB32_18 VGND WL_32 BLN_18 VGND sky130_fd_pr__nfet_01v8 w=0.42 l=0.17
XB32_19 VGND WL_32 BLN_19 VGND sky130_fd_pr__nfet_01v8 w=0.42 l=0.17
XB32_20 VGND WL_32 BLP_20 VGND sky130_fd_pr__nfet_01v8 w=0.42 l=0.17
XB32_21 VGND WL_32 nc_32_21 VGND sky130_fd_pr__nfet_01v8 w=0.42 l=0.17
XB32_22 VGND WL_32 nc_32_22 VGND sky130_fd_pr__nfet_01v8 w=0.42 l=0.17
XB32_23 VGND WL_32 BLN_23 VGND sky130_fd_pr__nfet_01v8 w=0.42 l=0.17
XB32_24 VGND WL_32 nc_32_24 VGND sky130_fd_pr__nfet_01v8 w=0.42 l=0.17
XB32_25 VGND WL_32 BLN_25 VGND sky130_fd_pr__nfet_01v8 w=0.42 l=0.17
XB32_26 VGND WL_32 BLN_26 VGND sky130_fd_pr__nfet_01v8 w=0.42 l=0.17
XB32_27 VGND WL_32 nc_32_27 VGND sky130_fd_pr__nfet_01v8 w=0.42 l=0.17
XB32_28 VGND WL_32 BLP_28 VGND sky130_fd_pr__nfet_01v8 w=0.42 l=0.17
XB32_29 VGND WL_32 BLP_29 VGND sky130_fd_pr__nfet_01v8 w=0.42 l=0.17
XB32_30 VGND WL_32 nc_32_30 VGND sky130_fd_pr__nfet_01v8 w=0.42 l=0.17
XB32_31 VGND WL_32 nc_32_31 VGND sky130_fd_pr__nfet_01v8 w=0.42 l=0.17
XB33_0 VGND WL_33 nc_33_0 VGND sky130_fd_pr__nfet_01v8 w=0.42 l=0.17
XB33_1 VGND WL_33 BLP_1 VGND sky130_fd_pr__nfet_01v8 w=0.42 l=0.17
XB33_2 VGND WL_33 nc_33_2 VGND sky130_fd_pr__nfet_01v8 w=0.42 l=0.17
XB33_3 VGND WL_33 BLP_3 VGND sky130_fd_pr__nfet_01v8 w=0.42 l=0.17
XB33_4 VGND WL_33 BLN_4 VGND sky130_fd_pr__nfet_01v8 w=0.42 l=0.17
XB33_5 VGND WL_33 BLP_5 VGND sky130_fd_pr__nfet_01v8 w=0.42 l=0.17
XB33_6 VGND WL_33 nc_33_6 VGND sky130_fd_pr__nfet_01v8 w=0.42 l=0.17
XB33_7 VGND WL_33 nc_33_7 VGND sky130_fd_pr__nfet_01v8 w=0.42 l=0.17
XB33_8 VGND WL_33 nc_33_8 VGND sky130_fd_pr__nfet_01v8 w=0.42 l=0.17
XB33_9 VGND WL_33 BLN_9 VGND sky130_fd_pr__nfet_01v8 w=0.42 l=0.17
XB33_10 VGND WL_33 nc_33_10 VGND sky130_fd_pr__nfet_01v8 w=0.42 l=0.17
XB33_11 VGND WL_33 nc_33_11 VGND sky130_fd_pr__nfet_01v8 w=0.42 l=0.17
XB33_12 VGND WL_33 BLN_12 VGND sky130_fd_pr__nfet_01v8 w=0.42 l=0.17
XB33_13 VGND WL_33 nc_33_13 VGND sky130_fd_pr__nfet_01v8 w=0.42 l=0.17
XB33_14 VGND WL_33 nc_33_14 VGND sky130_fd_pr__nfet_01v8 w=0.42 l=0.17
XB33_15 VGND WL_33 BLP_15 VGND sky130_fd_pr__nfet_01v8 w=0.42 l=0.17
XB33_16 VGND WL_33 nc_33_16 VGND sky130_fd_pr__nfet_01v8 w=0.42 l=0.17
XB33_17 VGND WL_33 BLN_17 VGND sky130_fd_pr__nfet_01v8 w=0.42 l=0.17
XB33_18 VGND WL_33 nc_33_18 VGND sky130_fd_pr__nfet_01v8 w=0.42 l=0.17
XB33_19 VGND WL_33 nc_33_19 VGND sky130_fd_pr__nfet_01v8 w=0.42 l=0.17
XB33_20 VGND WL_33 BLN_20 VGND sky130_fd_pr__nfet_01v8 w=0.42 l=0.17
XB33_21 VGND WL_33 nc_33_21 VGND sky130_fd_pr__nfet_01v8 w=0.42 l=0.17
XB33_22 VGND WL_33 BLP_22 VGND sky130_fd_pr__nfet_01v8 w=0.42 l=0.17
XB33_23 VGND WL_33 BLP_23 VGND sky130_fd_pr__nfet_01v8 w=0.42 l=0.17
XB33_24 VGND WL_33 BLP_24 VGND sky130_fd_pr__nfet_01v8 w=0.42 l=0.17
XB33_25 VGND WL_33 BLN_25 VGND sky130_fd_pr__nfet_01v8 w=0.42 l=0.17
XB33_26 VGND WL_33 nc_33_26 VGND sky130_fd_pr__nfet_01v8 w=0.42 l=0.17
XB33_27 VGND WL_33 BLN_27 VGND sky130_fd_pr__nfet_01v8 w=0.42 l=0.17
XB33_28 VGND WL_33 BLN_28 VGND sky130_fd_pr__nfet_01v8 w=0.42 l=0.17
XB33_29 VGND WL_33 BLN_29 VGND sky130_fd_pr__nfet_01v8 w=0.42 l=0.17
XB33_30 VGND WL_33 nc_33_30 VGND sky130_fd_pr__nfet_01v8 w=0.42 l=0.17
XB33_31 VGND WL_33 BLP_31 VGND sky130_fd_pr__nfet_01v8 w=0.42 l=0.17
XB34_0 VGND WL_34 nc_34_0 VGND sky130_fd_pr__nfet_01v8 w=0.42 l=0.17
XB34_1 VGND WL_34 BLN_1 VGND sky130_fd_pr__nfet_01v8 w=0.42 l=0.17
XB34_2 VGND WL_34 nc_34_2 VGND sky130_fd_pr__nfet_01v8 w=0.42 l=0.17
XB34_3 VGND WL_34 nc_34_3 VGND sky130_fd_pr__nfet_01v8 w=0.42 l=0.17
XB34_4 VGND WL_34 BLN_4 VGND sky130_fd_pr__nfet_01v8 w=0.42 l=0.17
XB34_5 VGND WL_34 nc_34_5 VGND sky130_fd_pr__nfet_01v8 w=0.42 l=0.17
XB34_6 VGND WL_34 BLP_6 VGND sky130_fd_pr__nfet_01v8 w=0.42 l=0.17
XB34_7 VGND WL_34 BLP_7 VGND sky130_fd_pr__nfet_01v8 w=0.42 l=0.17
XB34_8 VGND WL_34 nc_34_8 VGND sky130_fd_pr__nfet_01v8 w=0.42 l=0.17
XB34_9 VGND WL_34 BLP_9 VGND sky130_fd_pr__nfet_01v8 w=0.42 l=0.17
XB34_10 VGND WL_34 BLP_10 VGND sky130_fd_pr__nfet_01v8 w=0.42 l=0.17
XB34_11 VGND WL_34 BLP_11 VGND sky130_fd_pr__nfet_01v8 w=0.42 l=0.17
XB34_12 VGND WL_34 BLN_12 VGND sky130_fd_pr__nfet_01v8 w=0.42 l=0.17
XB34_13 VGND WL_34 nc_34_13 VGND sky130_fd_pr__nfet_01v8 w=0.42 l=0.17
XB34_14 VGND WL_34 nc_34_14 VGND sky130_fd_pr__nfet_01v8 w=0.42 l=0.17
XB34_15 VGND WL_34 nc_34_15 VGND sky130_fd_pr__nfet_01v8 w=0.42 l=0.17
XB34_16 VGND WL_34 BLN_16 VGND sky130_fd_pr__nfet_01v8 w=0.42 l=0.17
XB34_17 VGND WL_34 nc_34_17 VGND sky130_fd_pr__nfet_01v8 w=0.42 l=0.17
XB34_18 VGND WL_34 BLN_18 VGND sky130_fd_pr__nfet_01v8 w=0.42 l=0.17
XB34_19 VGND WL_34 nc_34_19 VGND sky130_fd_pr__nfet_01v8 w=0.42 l=0.17
XB34_20 VGND WL_34 BLP_20 VGND sky130_fd_pr__nfet_01v8 w=0.42 l=0.17
XB34_21 VGND WL_34 BLN_21 VGND sky130_fd_pr__nfet_01v8 w=0.42 l=0.17
XB34_22 VGND WL_34 nc_34_22 VGND sky130_fd_pr__nfet_01v8 w=0.42 l=0.17
XB34_23 VGND WL_34 nc_34_23 VGND sky130_fd_pr__nfet_01v8 w=0.42 l=0.17
XB34_24 VGND WL_34 nc_34_24 VGND sky130_fd_pr__nfet_01v8 w=0.42 l=0.17
XB34_25 VGND WL_34 nc_34_25 VGND sky130_fd_pr__nfet_01v8 w=0.42 l=0.17
XB34_26 VGND WL_34 BLN_26 VGND sky130_fd_pr__nfet_01v8 w=0.42 l=0.17
XB34_27 VGND WL_34 nc_34_27 VGND sky130_fd_pr__nfet_01v8 w=0.42 l=0.17
XB34_28 VGND WL_34 BLN_28 VGND sky130_fd_pr__nfet_01v8 w=0.42 l=0.17
XB34_29 VGND WL_34 BLP_29 VGND sky130_fd_pr__nfet_01v8 w=0.42 l=0.17
XB34_30 VGND WL_34 BLN_30 VGND sky130_fd_pr__nfet_01v8 w=0.42 l=0.17
XB34_31 VGND WL_34 BLN_31 VGND sky130_fd_pr__nfet_01v8 w=0.42 l=0.17
XB35_0 VGND WL_35 nc_35_0 VGND sky130_fd_pr__nfet_01v8 w=0.42 l=0.17
XB35_1 VGND WL_35 nc_35_1 VGND sky130_fd_pr__nfet_01v8 w=0.42 l=0.17
XB35_2 VGND WL_35 nc_35_2 VGND sky130_fd_pr__nfet_01v8 w=0.42 l=0.17
XB35_3 VGND WL_35 nc_35_3 VGND sky130_fd_pr__nfet_01v8 w=0.42 l=0.17
XB35_4 VGND WL_35 BLN_4 VGND sky130_fd_pr__nfet_01v8 w=0.42 l=0.17
XB35_5 VGND WL_35 nc_35_5 VGND sky130_fd_pr__nfet_01v8 w=0.42 l=0.17
XB35_6 VGND WL_35 nc_35_6 VGND sky130_fd_pr__nfet_01v8 w=0.42 l=0.17
XB35_7 VGND WL_35 nc_35_7 VGND sky130_fd_pr__nfet_01v8 w=0.42 l=0.17
XB35_8 VGND WL_35 nc_35_8 VGND sky130_fd_pr__nfet_01v8 w=0.42 l=0.17
XB35_9 VGND WL_35 nc_35_9 VGND sky130_fd_pr__nfet_01v8 w=0.42 l=0.17
XB35_10 VGND WL_35 BLN_10 VGND sky130_fd_pr__nfet_01v8 w=0.42 l=0.17
XB35_11 VGND WL_35 nc_35_11 VGND sky130_fd_pr__nfet_01v8 w=0.42 l=0.17
XB35_12 VGND WL_35 BLN_12 VGND sky130_fd_pr__nfet_01v8 w=0.42 l=0.17
XB35_13 VGND WL_35 nc_35_13 VGND sky130_fd_pr__nfet_01v8 w=0.42 l=0.17
XB35_14 VGND WL_35 BLN_14 VGND sky130_fd_pr__nfet_01v8 w=0.42 l=0.17
XB35_15 VGND WL_35 BLN_15 VGND sky130_fd_pr__nfet_01v8 w=0.42 l=0.17
XB35_16 VGND WL_35 nc_35_16 VGND sky130_fd_pr__nfet_01v8 w=0.42 l=0.17
XB35_17 VGND WL_35 nc_35_17 VGND sky130_fd_pr__nfet_01v8 w=0.42 l=0.17
XB35_18 VGND WL_35 BLP_18 VGND sky130_fd_pr__nfet_01v8 w=0.42 l=0.17
XB35_19 VGND WL_35 nc_35_19 VGND sky130_fd_pr__nfet_01v8 w=0.42 l=0.17
XB35_20 VGND WL_35 BLN_20 VGND sky130_fd_pr__nfet_01v8 w=0.42 l=0.17
XB35_21 VGND WL_35 nc_35_21 VGND sky130_fd_pr__nfet_01v8 w=0.42 l=0.17
XB35_22 VGND WL_35 nc_35_22 VGND sky130_fd_pr__nfet_01v8 w=0.42 l=0.17
XB35_23 VGND WL_35 nc_35_23 VGND sky130_fd_pr__nfet_01v8 w=0.42 l=0.17
XB35_24 VGND WL_35 nc_35_24 VGND sky130_fd_pr__nfet_01v8 w=0.42 l=0.17
XB35_25 VGND WL_35 BLN_25 VGND sky130_fd_pr__nfet_01v8 w=0.42 l=0.17
XB35_26 VGND WL_35 BLP_26 VGND sky130_fd_pr__nfet_01v8 w=0.42 l=0.17
XB35_27 VGND WL_35 nc_35_27 VGND sky130_fd_pr__nfet_01v8 w=0.42 l=0.17
XB35_28 VGND WL_35 BLP_28 VGND sky130_fd_pr__nfet_01v8 w=0.42 l=0.17
XB35_29 VGND WL_35 nc_35_29 VGND sky130_fd_pr__nfet_01v8 w=0.42 l=0.17
XB35_30 VGND WL_35 BLN_30 VGND sky130_fd_pr__nfet_01v8 w=0.42 l=0.17
XB35_31 VGND WL_35 BLP_31 VGND sky130_fd_pr__nfet_01v8 w=0.42 l=0.17
XB36_0 VGND WL_36 BLN_0 VGND sky130_fd_pr__nfet_01v8 w=0.42 l=0.17
XB36_1 VGND WL_36 nc_36_1 VGND sky130_fd_pr__nfet_01v8 w=0.42 l=0.17
XB36_2 VGND WL_36 nc_36_2 VGND sky130_fd_pr__nfet_01v8 w=0.42 l=0.17
XB36_3 VGND WL_36 nc_36_3 VGND sky130_fd_pr__nfet_01v8 w=0.42 l=0.17
XB36_4 VGND WL_36 nc_36_4 VGND sky130_fd_pr__nfet_01v8 w=0.42 l=0.17
XB36_5 VGND WL_36 nc_36_5 VGND sky130_fd_pr__nfet_01v8 w=0.42 l=0.17
XB36_6 VGND WL_36 nc_36_6 VGND sky130_fd_pr__nfet_01v8 w=0.42 l=0.17
XB36_7 VGND WL_36 BLP_7 VGND sky130_fd_pr__nfet_01v8 w=0.42 l=0.17
XB36_8 VGND WL_36 BLP_8 VGND sky130_fd_pr__nfet_01v8 w=0.42 l=0.17
XB36_9 VGND WL_36 nc_36_9 VGND sky130_fd_pr__nfet_01v8 w=0.42 l=0.17
XB36_10 VGND WL_36 BLN_10 VGND sky130_fd_pr__nfet_01v8 w=0.42 l=0.17
XB36_11 VGND WL_36 nc_36_11 VGND sky130_fd_pr__nfet_01v8 w=0.42 l=0.17
XB36_12 VGND WL_36 nc_36_12 VGND sky130_fd_pr__nfet_01v8 w=0.42 l=0.17
XB36_13 VGND WL_36 nc_36_13 VGND sky130_fd_pr__nfet_01v8 w=0.42 l=0.17
XB36_14 VGND WL_36 nc_36_14 VGND sky130_fd_pr__nfet_01v8 w=0.42 l=0.17
XB36_15 VGND WL_36 BLP_15 VGND sky130_fd_pr__nfet_01v8 w=0.42 l=0.17
XB36_16 VGND WL_36 BLP_16 VGND sky130_fd_pr__nfet_01v8 w=0.42 l=0.17
XB36_17 VGND WL_36 BLP_17 VGND sky130_fd_pr__nfet_01v8 w=0.42 l=0.17
XB36_18 VGND WL_36 nc_36_18 VGND sky130_fd_pr__nfet_01v8 w=0.42 l=0.17
XB36_19 VGND WL_36 nc_36_19 VGND sky130_fd_pr__nfet_01v8 w=0.42 l=0.17
XB36_20 VGND WL_36 nc_36_20 VGND sky130_fd_pr__nfet_01v8 w=0.42 l=0.17
XB36_21 VGND WL_36 BLN_21 VGND sky130_fd_pr__nfet_01v8 w=0.42 l=0.17
XB36_22 VGND WL_36 nc_36_22 VGND sky130_fd_pr__nfet_01v8 w=0.42 l=0.17
XB36_23 VGND WL_36 nc_36_23 VGND sky130_fd_pr__nfet_01v8 w=0.42 l=0.17
XB36_24 VGND WL_36 nc_36_24 VGND sky130_fd_pr__nfet_01v8 w=0.42 l=0.17
XB36_25 VGND WL_36 BLN_25 VGND sky130_fd_pr__nfet_01v8 w=0.42 l=0.17
XB36_26 VGND WL_36 BLN_26 VGND sky130_fd_pr__nfet_01v8 w=0.42 l=0.17
XB36_27 VGND WL_36 BLP_27 VGND sky130_fd_pr__nfet_01v8 w=0.42 l=0.17
XB36_28 VGND WL_36 nc_36_28 VGND sky130_fd_pr__nfet_01v8 w=0.42 l=0.17
XB36_29 VGND WL_36 nc_36_29 VGND sky130_fd_pr__nfet_01v8 w=0.42 l=0.17
XB36_30 VGND WL_36 nc_36_30 VGND sky130_fd_pr__nfet_01v8 w=0.42 l=0.17
XB36_31 VGND WL_36 BLN_31 VGND sky130_fd_pr__nfet_01v8 w=0.42 l=0.17
XB37_0 VGND WL_37 nc_37_0 VGND sky130_fd_pr__nfet_01v8 w=0.42 l=0.17
XB37_1 VGND WL_37 nc_37_1 VGND sky130_fd_pr__nfet_01v8 w=0.42 l=0.17
XB37_2 VGND WL_37 BLP_2 VGND sky130_fd_pr__nfet_01v8 w=0.42 l=0.17
XB37_3 VGND WL_37 BLN_3 VGND sky130_fd_pr__nfet_01v8 w=0.42 l=0.17
XB37_4 VGND WL_37 nc_37_4 VGND sky130_fd_pr__nfet_01v8 w=0.42 l=0.17
XB37_5 VGND WL_37 BLP_5 VGND sky130_fd_pr__nfet_01v8 w=0.42 l=0.17
XB37_6 VGND WL_37 BLP_6 VGND sky130_fd_pr__nfet_01v8 w=0.42 l=0.17
XB37_7 VGND WL_37 BLN_7 VGND sky130_fd_pr__nfet_01v8 w=0.42 l=0.17
XB37_8 VGND WL_37 BLN_8 VGND sky130_fd_pr__nfet_01v8 w=0.42 l=0.17
XB37_9 VGND WL_37 BLP_9 VGND sky130_fd_pr__nfet_01v8 w=0.42 l=0.17
XB37_10 VGND WL_37 nc_37_10 VGND sky130_fd_pr__nfet_01v8 w=0.42 l=0.17
XB37_11 VGND WL_37 BLN_11 VGND sky130_fd_pr__nfet_01v8 w=0.42 l=0.17
XB37_12 VGND WL_37 nc_37_12 VGND sky130_fd_pr__nfet_01v8 w=0.42 l=0.17
XB37_13 VGND WL_37 BLN_13 VGND sky130_fd_pr__nfet_01v8 w=0.42 l=0.17
XB37_14 VGND WL_37 nc_37_14 VGND sky130_fd_pr__nfet_01v8 w=0.42 l=0.17
XB37_15 VGND WL_37 BLP_15 VGND sky130_fd_pr__nfet_01v8 w=0.42 l=0.17
XB37_16 VGND WL_37 BLN_16 VGND sky130_fd_pr__nfet_01v8 w=0.42 l=0.17
XB37_17 VGND WL_37 BLN_17 VGND sky130_fd_pr__nfet_01v8 w=0.42 l=0.17
XB37_18 VGND WL_37 nc_37_18 VGND sky130_fd_pr__nfet_01v8 w=0.42 l=0.17
XB37_19 VGND WL_37 nc_37_19 VGND sky130_fd_pr__nfet_01v8 w=0.42 l=0.17
XB37_20 VGND WL_37 BLP_20 VGND sky130_fd_pr__nfet_01v8 w=0.42 l=0.17
XB37_21 VGND WL_37 BLN_21 VGND sky130_fd_pr__nfet_01v8 w=0.42 l=0.17
XB37_22 VGND WL_37 nc_37_22 VGND sky130_fd_pr__nfet_01v8 w=0.42 l=0.17
XB37_23 VGND WL_37 BLP_23 VGND sky130_fd_pr__nfet_01v8 w=0.42 l=0.17
XB37_24 VGND WL_37 BLP_24 VGND sky130_fd_pr__nfet_01v8 w=0.42 l=0.17
XB37_25 VGND WL_37 nc_37_25 VGND sky130_fd_pr__nfet_01v8 w=0.42 l=0.17
XB37_26 VGND WL_37 nc_37_26 VGND sky130_fd_pr__nfet_01v8 w=0.42 l=0.17
XB37_27 VGND WL_37 nc_37_27 VGND sky130_fd_pr__nfet_01v8 w=0.42 l=0.17
XB37_28 VGND WL_37 nc_37_28 VGND sky130_fd_pr__nfet_01v8 w=0.42 l=0.17
XB37_29 VGND WL_37 nc_37_29 VGND sky130_fd_pr__nfet_01v8 w=0.42 l=0.17
XB37_30 VGND WL_37 nc_37_30 VGND sky130_fd_pr__nfet_01v8 w=0.42 l=0.17
XB37_31 VGND WL_37 nc_37_31 VGND sky130_fd_pr__nfet_01v8 w=0.42 l=0.17
XB38_0 VGND WL_38 BLN_0 VGND sky130_fd_pr__nfet_01v8 w=0.42 l=0.17
XB38_1 VGND WL_38 BLN_1 VGND sky130_fd_pr__nfet_01v8 w=0.42 l=0.17
XB38_2 VGND WL_38 nc_38_2 VGND sky130_fd_pr__nfet_01v8 w=0.42 l=0.17
XB38_3 VGND WL_38 nc_38_3 VGND sky130_fd_pr__nfet_01v8 w=0.42 l=0.17
XB38_4 VGND WL_38 BLN_4 VGND sky130_fd_pr__nfet_01v8 w=0.42 l=0.17
XB38_5 VGND WL_38 BLP_5 VGND sky130_fd_pr__nfet_01v8 w=0.42 l=0.17
XB38_6 VGND WL_38 nc_38_6 VGND sky130_fd_pr__nfet_01v8 w=0.42 l=0.17
XB38_7 VGND WL_38 BLN_7 VGND sky130_fd_pr__nfet_01v8 w=0.42 l=0.17
XB38_8 VGND WL_38 BLP_8 VGND sky130_fd_pr__nfet_01v8 w=0.42 l=0.17
XB38_9 VGND WL_38 nc_38_9 VGND sky130_fd_pr__nfet_01v8 w=0.42 l=0.17
XB38_10 VGND WL_38 nc_38_10 VGND sky130_fd_pr__nfet_01v8 w=0.42 l=0.17
XB38_11 VGND WL_38 BLP_11 VGND sky130_fd_pr__nfet_01v8 w=0.42 l=0.17
XB38_12 VGND WL_38 BLN_12 VGND sky130_fd_pr__nfet_01v8 w=0.42 l=0.17
XB38_13 VGND WL_38 BLP_13 VGND sky130_fd_pr__nfet_01v8 w=0.42 l=0.17
XB38_14 VGND WL_38 BLP_14 VGND sky130_fd_pr__nfet_01v8 w=0.42 l=0.17
XB38_15 VGND WL_38 BLP_15 VGND sky130_fd_pr__nfet_01v8 w=0.42 l=0.17
XB38_16 VGND WL_38 nc_38_16 VGND sky130_fd_pr__nfet_01v8 w=0.42 l=0.17
XB38_17 VGND WL_38 BLP_17 VGND sky130_fd_pr__nfet_01v8 w=0.42 l=0.17
XB38_18 VGND WL_38 nc_38_18 VGND sky130_fd_pr__nfet_01v8 w=0.42 l=0.17
XB38_19 VGND WL_38 BLN_19 VGND sky130_fd_pr__nfet_01v8 w=0.42 l=0.17
XB38_20 VGND WL_38 nc_38_20 VGND sky130_fd_pr__nfet_01v8 w=0.42 l=0.17
XB38_21 VGND WL_38 BLN_21 VGND sky130_fd_pr__nfet_01v8 w=0.42 l=0.17
XB38_22 VGND WL_38 nc_38_22 VGND sky130_fd_pr__nfet_01v8 w=0.42 l=0.17
XB38_23 VGND WL_38 nc_38_23 VGND sky130_fd_pr__nfet_01v8 w=0.42 l=0.17
XB38_24 VGND WL_38 nc_38_24 VGND sky130_fd_pr__nfet_01v8 w=0.42 l=0.17
XB38_25 VGND WL_38 nc_38_25 VGND sky130_fd_pr__nfet_01v8 w=0.42 l=0.17
XB38_26 VGND WL_38 nc_38_26 VGND sky130_fd_pr__nfet_01v8 w=0.42 l=0.17
XB38_27 VGND WL_38 nc_38_27 VGND sky130_fd_pr__nfet_01v8 w=0.42 l=0.17
XB38_28 VGND WL_38 BLP_28 VGND sky130_fd_pr__nfet_01v8 w=0.42 l=0.17
XB38_29 VGND WL_38 nc_38_29 VGND sky130_fd_pr__nfet_01v8 w=0.42 l=0.17
XB38_30 VGND WL_38 BLN_30 VGND sky130_fd_pr__nfet_01v8 w=0.42 l=0.17
XB38_31 VGND WL_38 nc_38_31 VGND sky130_fd_pr__nfet_01v8 w=0.42 l=0.17
XB39_0 VGND WL_39 nc_39_0 VGND sky130_fd_pr__nfet_01v8 w=0.42 l=0.17
XB39_1 VGND WL_39 nc_39_1 VGND sky130_fd_pr__nfet_01v8 w=0.42 l=0.17
XB39_2 VGND WL_39 BLP_2 VGND sky130_fd_pr__nfet_01v8 w=0.42 l=0.17
XB39_3 VGND WL_39 BLP_3 VGND sky130_fd_pr__nfet_01v8 w=0.42 l=0.17
XB39_4 VGND WL_39 nc_39_4 VGND sky130_fd_pr__nfet_01v8 w=0.42 l=0.17
XB39_5 VGND WL_39 nc_39_5 VGND sky130_fd_pr__nfet_01v8 w=0.42 l=0.17
XB39_6 VGND WL_39 nc_39_6 VGND sky130_fd_pr__nfet_01v8 w=0.42 l=0.17
XB39_7 VGND WL_39 BLN_7 VGND sky130_fd_pr__nfet_01v8 w=0.42 l=0.17
XB39_8 VGND WL_39 nc_39_8 VGND sky130_fd_pr__nfet_01v8 w=0.42 l=0.17
XB39_9 VGND WL_39 BLP_9 VGND sky130_fd_pr__nfet_01v8 w=0.42 l=0.17
XB39_10 VGND WL_39 nc_39_10 VGND sky130_fd_pr__nfet_01v8 w=0.42 l=0.17
XB39_11 VGND WL_39 BLP_11 VGND sky130_fd_pr__nfet_01v8 w=0.42 l=0.17
XB39_12 VGND WL_39 BLN_12 VGND sky130_fd_pr__nfet_01v8 w=0.42 l=0.17
XB39_13 VGND WL_39 nc_39_13 VGND sky130_fd_pr__nfet_01v8 w=0.42 l=0.17
XB39_14 VGND WL_39 BLP_14 VGND sky130_fd_pr__nfet_01v8 w=0.42 l=0.17
XB39_15 VGND WL_39 nc_39_15 VGND sky130_fd_pr__nfet_01v8 w=0.42 l=0.17
XB39_16 VGND WL_39 nc_39_16 VGND sky130_fd_pr__nfet_01v8 w=0.42 l=0.17
XB39_17 VGND WL_39 nc_39_17 VGND sky130_fd_pr__nfet_01v8 w=0.42 l=0.17
XB39_18 VGND WL_39 nc_39_18 VGND sky130_fd_pr__nfet_01v8 w=0.42 l=0.17
XB39_19 VGND WL_39 BLN_19 VGND sky130_fd_pr__nfet_01v8 w=0.42 l=0.17
XB39_20 VGND WL_39 BLN_20 VGND sky130_fd_pr__nfet_01v8 w=0.42 l=0.17
XB39_21 VGND WL_39 BLN_21 VGND sky130_fd_pr__nfet_01v8 w=0.42 l=0.17
XB39_22 VGND WL_39 nc_39_22 VGND sky130_fd_pr__nfet_01v8 w=0.42 l=0.17
XB39_23 VGND WL_39 BLN_23 VGND sky130_fd_pr__nfet_01v8 w=0.42 l=0.17
XB39_24 VGND WL_39 BLN_24 VGND sky130_fd_pr__nfet_01v8 w=0.42 l=0.17
XB39_25 VGND WL_39 BLP_25 VGND sky130_fd_pr__nfet_01v8 w=0.42 l=0.17
XB39_26 VGND WL_39 BLP_26 VGND sky130_fd_pr__nfet_01v8 w=0.42 l=0.17
XB39_27 VGND WL_39 BLN_27 VGND sky130_fd_pr__nfet_01v8 w=0.42 l=0.17
XB39_28 VGND WL_39 nc_39_28 VGND sky130_fd_pr__nfet_01v8 w=0.42 l=0.17
XB39_29 VGND WL_39 nc_39_29 VGND sky130_fd_pr__nfet_01v8 w=0.42 l=0.17
XB39_30 VGND WL_39 BLN_30 VGND sky130_fd_pr__nfet_01v8 w=0.42 l=0.17
XB39_31 VGND WL_39 nc_39_31 VGND sky130_fd_pr__nfet_01v8 w=0.42 l=0.17
XB40_0 VGND WL_40 nc_40_0 VGND sky130_fd_pr__nfet_01v8 w=0.42 l=0.17
XB40_1 VGND WL_40 nc_40_1 VGND sky130_fd_pr__nfet_01v8 w=0.42 l=0.17
XB40_2 VGND WL_40 nc_40_2 VGND sky130_fd_pr__nfet_01v8 w=0.42 l=0.17
XB40_3 VGND WL_40 BLP_3 VGND sky130_fd_pr__nfet_01v8 w=0.42 l=0.17
XB40_4 VGND WL_40 BLP_4 VGND sky130_fd_pr__nfet_01v8 w=0.42 l=0.17
XB40_5 VGND WL_40 nc_40_5 VGND sky130_fd_pr__nfet_01v8 w=0.42 l=0.17
XB40_6 VGND WL_40 BLN_6 VGND sky130_fd_pr__nfet_01v8 w=0.42 l=0.17
XB40_7 VGND WL_40 BLN_7 VGND sky130_fd_pr__nfet_01v8 w=0.42 l=0.17
XB40_8 VGND WL_40 BLP_8 VGND sky130_fd_pr__nfet_01v8 w=0.42 l=0.17
XB40_9 VGND WL_40 nc_40_9 VGND sky130_fd_pr__nfet_01v8 w=0.42 l=0.17
XB40_10 VGND WL_40 BLP_10 VGND sky130_fd_pr__nfet_01v8 w=0.42 l=0.17
XB40_11 VGND WL_40 BLP_11 VGND sky130_fd_pr__nfet_01v8 w=0.42 l=0.17
XB40_12 VGND WL_40 BLN_12 VGND sky130_fd_pr__nfet_01v8 w=0.42 l=0.17
XB40_13 VGND WL_40 nc_40_13 VGND sky130_fd_pr__nfet_01v8 w=0.42 l=0.17
XB40_14 VGND WL_40 nc_40_14 VGND sky130_fd_pr__nfet_01v8 w=0.42 l=0.17
XB40_15 VGND WL_40 BLN_15 VGND sky130_fd_pr__nfet_01v8 w=0.42 l=0.17
XB40_16 VGND WL_40 nc_40_16 VGND sky130_fd_pr__nfet_01v8 w=0.42 l=0.17
XB40_17 VGND WL_40 BLN_17 VGND sky130_fd_pr__nfet_01v8 w=0.42 l=0.17
XB40_18 VGND WL_40 nc_40_18 VGND sky130_fd_pr__nfet_01v8 w=0.42 l=0.17
XB40_19 VGND WL_40 BLN_19 VGND sky130_fd_pr__nfet_01v8 w=0.42 l=0.17
XB40_20 VGND WL_40 nc_40_20 VGND sky130_fd_pr__nfet_01v8 w=0.42 l=0.17
XB40_21 VGND WL_40 nc_40_21 VGND sky130_fd_pr__nfet_01v8 w=0.42 l=0.17
XB40_22 VGND WL_40 BLP_22 VGND sky130_fd_pr__nfet_01v8 w=0.42 l=0.17
XB40_23 VGND WL_40 BLP_23 VGND sky130_fd_pr__nfet_01v8 w=0.42 l=0.17
XB40_24 VGND WL_40 BLP_24 VGND sky130_fd_pr__nfet_01v8 w=0.42 l=0.17
XB40_25 VGND WL_40 BLN_25 VGND sky130_fd_pr__nfet_01v8 w=0.42 l=0.17
XB40_26 VGND WL_40 nc_40_26 VGND sky130_fd_pr__nfet_01v8 w=0.42 l=0.17
XB40_27 VGND WL_40 nc_40_27 VGND sky130_fd_pr__nfet_01v8 w=0.42 l=0.17
XB40_28 VGND WL_40 nc_40_28 VGND sky130_fd_pr__nfet_01v8 w=0.42 l=0.17
XB40_29 VGND WL_40 nc_40_29 VGND sky130_fd_pr__nfet_01v8 w=0.42 l=0.17
XB40_30 VGND WL_40 BLN_30 VGND sky130_fd_pr__nfet_01v8 w=0.42 l=0.17
XB40_31 VGND WL_40 nc_40_31 VGND sky130_fd_pr__nfet_01v8 w=0.42 l=0.17
XB41_0 VGND WL_41 nc_41_0 VGND sky130_fd_pr__nfet_01v8 w=0.42 l=0.17
XB41_1 VGND WL_41 BLP_1 VGND sky130_fd_pr__nfet_01v8 w=0.42 l=0.17
XB41_2 VGND WL_41 nc_41_2 VGND sky130_fd_pr__nfet_01v8 w=0.42 l=0.17
XB41_3 VGND WL_41 BLP_3 VGND sky130_fd_pr__nfet_01v8 w=0.42 l=0.17
XB41_4 VGND WL_41 nc_41_4 VGND sky130_fd_pr__nfet_01v8 w=0.42 l=0.17
XB41_5 VGND WL_41 BLP_5 VGND sky130_fd_pr__nfet_01v8 w=0.42 l=0.17
XB41_6 VGND WL_41 BLP_6 VGND sky130_fd_pr__nfet_01v8 w=0.42 l=0.17
XB41_7 VGND WL_41 BLP_7 VGND sky130_fd_pr__nfet_01v8 w=0.42 l=0.17
XB41_8 VGND WL_41 nc_41_8 VGND sky130_fd_pr__nfet_01v8 w=0.42 l=0.17
XB41_9 VGND WL_41 BLN_9 VGND sky130_fd_pr__nfet_01v8 w=0.42 l=0.17
XB41_10 VGND WL_41 BLP_10 VGND sky130_fd_pr__nfet_01v8 w=0.42 l=0.17
XB41_11 VGND WL_41 BLP_11 VGND sky130_fd_pr__nfet_01v8 w=0.42 l=0.17
XB41_12 VGND WL_41 nc_41_12 VGND sky130_fd_pr__nfet_01v8 w=0.42 l=0.17
XB41_13 VGND WL_41 nc_41_13 VGND sky130_fd_pr__nfet_01v8 w=0.42 l=0.17
XB41_14 VGND WL_41 nc_41_14 VGND sky130_fd_pr__nfet_01v8 w=0.42 l=0.17
XB41_15 VGND WL_41 BLP_15 VGND sky130_fd_pr__nfet_01v8 w=0.42 l=0.17
XB41_16 VGND WL_41 BLN_16 VGND sky130_fd_pr__nfet_01v8 w=0.42 l=0.17
XB41_17 VGND WL_41 BLN_17 VGND sky130_fd_pr__nfet_01v8 w=0.42 l=0.17
XB41_18 VGND WL_41 BLP_18 VGND sky130_fd_pr__nfet_01v8 w=0.42 l=0.17
XB41_19 VGND WL_41 nc_41_19 VGND sky130_fd_pr__nfet_01v8 w=0.42 l=0.17
XB41_20 VGND WL_41 BLN_20 VGND sky130_fd_pr__nfet_01v8 w=0.42 l=0.17
XB41_21 VGND WL_41 nc_41_21 VGND sky130_fd_pr__nfet_01v8 w=0.42 l=0.17
XB41_22 VGND WL_41 nc_41_22 VGND sky130_fd_pr__nfet_01v8 w=0.42 l=0.17
XB41_23 VGND WL_41 BLP_23 VGND sky130_fd_pr__nfet_01v8 w=0.42 l=0.17
XB41_24 VGND WL_41 BLP_24 VGND sky130_fd_pr__nfet_01v8 w=0.42 l=0.17
XB41_25 VGND WL_41 BLN_25 VGND sky130_fd_pr__nfet_01v8 w=0.42 l=0.17
XB41_26 VGND WL_41 BLN_26 VGND sky130_fd_pr__nfet_01v8 w=0.42 l=0.17
XB41_27 VGND WL_41 nc_41_27 VGND sky130_fd_pr__nfet_01v8 w=0.42 l=0.17
XB41_28 VGND WL_41 nc_41_28 VGND sky130_fd_pr__nfet_01v8 w=0.42 l=0.17
XB41_29 VGND WL_41 BLP_29 VGND sky130_fd_pr__nfet_01v8 w=0.42 l=0.17
XB41_30 VGND WL_41 BLN_30 VGND sky130_fd_pr__nfet_01v8 w=0.42 l=0.17
XB41_31 VGND WL_41 BLP_31 VGND sky130_fd_pr__nfet_01v8 w=0.42 l=0.17
XB42_0 VGND WL_42 nc_42_0 VGND sky130_fd_pr__nfet_01v8 w=0.42 l=0.17
XB42_1 VGND WL_42 BLP_1 VGND sky130_fd_pr__nfet_01v8 w=0.42 l=0.17
XB42_2 VGND WL_42 BLP_2 VGND sky130_fd_pr__nfet_01v8 w=0.42 l=0.17
XB42_3 VGND WL_42 BLN_3 VGND sky130_fd_pr__nfet_01v8 w=0.42 l=0.17
XB42_4 VGND WL_42 nc_42_4 VGND sky130_fd_pr__nfet_01v8 w=0.42 l=0.17
XB42_5 VGND WL_42 nc_42_5 VGND sky130_fd_pr__nfet_01v8 w=0.42 l=0.17
XB42_6 VGND WL_42 BLP_6 VGND sky130_fd_pr__nfet_01v8 w=0.42 l=0.17
XB42_7 VGND WL_42 BLP_7 VGND sky130_fd_pr__nfet_01v8 w=0.42 l=0.17
XB42_8 VGND WL_42 nc_42_8 VGND sky130_fd_pr__nfet_01v8 w=0.42 l=0.17
XB42_9 VGND WL_42 BLP_9 VGND sky130_fd_pr__nfet_01v8 w=0.42 l=0.17
XB42_10 VGND WL_42 nc_42_10 VGND sky130_fd_pr__nfet_01v8 w=0.42 l=0.17
XB42_11 VGND WL_42 nc_42_11 VGND sky130_fd_pr__nfet_01v8 w=0.42 l=0.17
XB42_12 VGND WL_42 BLN_12 VGND sky130_fd_pr__nfet_01v8 w=0.42 l=0.17
XB42_13 VGND WL_42 BLN_13 VGND sky130_fd_pr__nfet_01v8 w=0.42 l=0.17
XB42_14 VGND WL_42 BLP_14 VGND sky130_fd_pr__nfet_01v8 w=0.42 l=0.17
XB42_15 VGND WL_42 BLP_15 VGND sky130_fd_pr__nfet_01v8 w=0.42 l=0.17
XB42_16 VGND WL_42 BLP_16 VGND sky130_fd_pr__nfet_01v8 w=0.42 l=0.17
XB42_17 VGND WL_42 nc_42_17 VGND sky130_fd_pr__nfet_01v8 w=0.42 l=0.17
XB42_18 VGND WL_42 BLP_18 VGND sky130_fd_pr__nfet_01v8 w=0.42 l=0.17
XB42_19 VGND WL_42 nc_42_19 VGND sky130_fd_pr__nfet_01v8 w=0.42 l=0.17
XB42_20 VGND WL_42 BLN_20 VGND sky130_fd_pr__nfet_01v8 w=0.42 l=0.17
XB42_21 VGND WL_42 BLN_21 VGND sky130_fd_pr__nfet_01v8 w=0.42 l=0.17
XB42_22 VGND WL_42 BLP_22 VGND sky130_fd_pr__nfet_01v8 w=0.42 l=0.17
XB42_23 VGND WL_42 BLN_23 VGND sky130_fd_pr__nfet_01v8 w=0.42 l=0.17
XB42_24 VGND WL_42 nc_42_24 VGND sky130_fd_pr__nfet_01v8 w=0.42 l=0.17
XB42_25 VGND WL_42 nc_42_25 VGND sky130_fd_pr__nfet_01v8 w=0.42 l=0.17
XB42_26 VGND WL_42 nc_42_26 VGND sky130_fd_pr__nfet_01v8 w=0.42 l=0.17
XB42_27 VGND WL_42 nc_42_27 VGND sky130_fd_pr__nfet_01v8 w=0.42 l=0.17
XB42_28 VGND WL_42 BLP_28 VGND sky130_fd_pr__nfet_01v8 w=0.42 l=0.17
XB42_29 VGND WL_42 nc_42_29 VGND sky130_fd_pr__nfet_01v8 w=0.42 l=0.17
XB42_30 VGND WL_42 nc_42_30 VGND sky130_fd_pr__nfet_01v8 w=0.42 l=0.17
XB42_31 VGND WL_42 nc_42_31 VGND sky130_fd_pr__nfet_01v8 w=0.42 l=0.17
XB43_0 VGND WL_43 BLP_0 VGND sky130_fd_pr__nfet_01v8 w=0.42 l=0.17
XB43_1 VGND WL_43 nc_43_1 VGND sky130_fd_pr__nfet_01v8 w=0.42 l=0.17
XB43_2 VGND WL_43 BLN_2 VGND sky130_fd_pr__nfet_01v8 w=0.42 l=0.17
XB43_3 VGND WL_43 nc_43_3 VGND sky130_fd_pr__nfet_01v8 w=0.42 l=0.17
XB43_4 VGND WL_43 BLP_4 VGND sky130_fd_pr__nfet_01v8 w=0.42 l=0.17
XB43_5 VGND WL_43 nc_43_5 VGND sky130_fd_pr__nfet_01v8 w=0.42 l=0.17
XB43_6 VGND WL_43 nc_43_6 VGND sky130_fd_pr__nfet_01v8 w=0.42 l=0.17
XB43_7 VGND WL_43 nc_43_7 VGND sky130_fd_pr__nfet_01v8 w=0.42 l=0.17
XB43_8 VGND WL_43 BLP_8 VGND sky130_fd_pr__nfet_01v8 w=0.42 l=0.17
XB43_9 VGND WL_43 BLN_9 VGND sky130_fd_pr__nfet_01v8 w=0.42 l=0.17
XB43_10 VGND WL_43 nc_43_10 VGND sky130_fd_pr__nfet_01v8 w=0.42 l=0.17
XB43_11 VGND WL_43 nc_43_11 VGND sky130_fd_pr__nfet_01v8 w=0.42 l=0.17
XB43_12 VGND WL_43 BLN_12 VGND sky130_fd_pr__nfet_01v8 w=0.42 l=0.17
XB43_13 VGND WL_43 BLP_13 VGND sky130_fd_pr__nfet_01v8 w=0.42 l=0.17
XB43_14 VGND WL_43 BLP_14 VGND sky130_fd_pr__nfet_01v8 w=0.42 l=0.17
XB43_15 VGND WL_43 BLP_15 VGND sky130_fd_pr__nfet_01v8 w=0.42 l=0.17
XB43_16 VGND WL_43 nc_43_16 VGND sky130_fd_pr__nfet_01v8 w=0.42 l=0.17
XB43_17 VGND WL_43 nc_43_17 VGND sky130_fd_pr__nfet_01v8 w=0.42 l=0.17
XB43_18 VGND WL_43 BLP_18 VGND sky130_fd_pr__nfet_01v8 w=0.42 l=0.17
XB43_19 VGND WL_43 nc_43_19 VGND sky130_fd_pr__nfet_01v8 w=0.42 l=0.17
XB43_20 VGND WL_43 nc_43_20 VGND sky130_fd_pr__nfet_01v8 w=0.42 l=0.17
XB43_21 VGND WL_43 BLN_21 VGND sky130_fd_pr__nfet_01v8 w=0.42 l=0.17
XB43_22 VGND WL_43 nc_43_22 VGND sky130_fd_pr__nfet_01v8 w=0.42 l=0.17
XB43_23 VGND WL_43 nc_43_23 VGND sky130_fd_pr__nfet_01v8 w=0.42 l=0.17
XB43_24 VGND WL_43 BLN_24 VGND sky130_fd_pr__nfet_01v8 w=0.42 l=0.17
XB43_25 VGND WL_43 BLN_25 VGND sky130_fd_pr__nfet_01v8 w=0.42 l=0.17
XB43_26 VGND WL_43 nc_43_26 VGND sky130_fd_pr__nfet_01v8 w=0.42 l=0.17
XB43_27 VGND WL_43 nc_43_27 VGND sky130_fd_pr__nfet_01v8 w=0.42 l=0.17
XB43_28 VGND WL_43 BLN_28 VGND sky130_fd_pr__nfet_01v8 w=0.42 l=0.17
XB43_29 VGND WL_43 nc_43_29 VGND sky130_fd_pr__nfet_01v8 w=0.42 l=0.17
XB43_30 VGND WL_43 BLN_30 VGND sky130_fd_pr__nfet_01v8 w=0.42 l=0.17
XB43_31 VGND WL_43 BLP_31 VGND sky130_fd_pr__nfet_01v8 w=0.42 l=0.17
XB44_0 VGND WL_44 nc_44_0 VGND sky130_fd_pr__nfet_01v8 w=0.42 l=0.17
XB44_1 VGND WL_44 BLP_1 VGND sky130_fd_pr__nfet_01v8 w=0.42 l=0.17
XB44_2 VGND WL_44 BLN_2 VGND sky130_fd_pr__nfet_01v8 w=0.42 l=0.17
XB44_3 VGND WL_44 BLN_3 VGND sky130_fd_pr__nfet_01v8 w=0.42 l=0.17
XB44_4 VGND WL_44 nc_44_4 VGND sky130_fd_pr__nfet_01v8 w=0.42 l=0.17
XB44_5 VGND WL_44 BLP_5 VGND sky130_fd_pr__nfet_01v8 w=0.42 l=0.17
XB44_6 VGND WL_44 BLN_6 VGND sky130_fd_pr__nfet_01v8 w=0.42 l=0.17
XB44_7 VGND WL_44 BLN_7 VGND sky130_fd_pr__nfet_01v8 w=0.42 l=0.17
XB44_8 VGND WL_44 nc_44_8 VGND sky130_fd_pr__nfet_01v8 w=0.42 l=0.17
XB44_9 VGND WL_44 nc_44_9 VGND sky130_fd_pr__nfet_01v8 w=0.42 l=0.17
XB44_10 VGND WL_44 nc_44_10 VGND sky130_fd_pr__nfet_01v8 w=0.42 l=0.17
XB44_11 VGND WL_44 nc_44_11 VGND sky130_fd_pr__nfet_01v8 w=0.42 l=0.17
XB44_12 VGND WL_44 nc_44_12 VGND sky130_fd_pr__nfet_01v8 w=0.42 l=0.17
XB44_13 VGND WL_44 nc_44_13 VGND sky130_fd_pr__nfet_01v8 w=0.42 l=0.17
XB44_14 VGND WL_44 BLP_14 VGND sky130_fd_pr__nfet_01v8 w=0.42 l=0.17
XB44_15 VGND WL_44 nc_44_15 VGND sky130_fd_pr__nfet_01v8 w=0.42 l=0.17
XB44_16 VGND WL_44 nc_44_16 VGND sky130_fd_pr__nfet_01v8 w=0.42 l=0.17
XB44_17 VGND WL_44 BLP_17 VGND sky130_fd_pr__nfet_01v8 w=0.42 l=0.17
XB44_18 VGND WL_44 nc_44_18 VGND sky130_fd_pr__nfet_01v8 w=0.42 l=0.17
XB44_19 VGND WL_44 BLP_19 VGND sky130_fd_pr__nfet_01v8 w=0.42 l=0.17
XB44_20 VGND WL_44 nc_44_20 VGND sky130_fd_pr__nfet_01v8 w=0.42 l=0.17
XB44_21 VGND WL_44 BLP_21 VGND sky130_fd_pr__nfet_01v8 w=0.42 l=0.17
XB44_22 VGND WL_44 nc_44_22 VGND sky130_fd_pr__nfet_01v8 w=0.42 l=0.17
XB44_23 VGND WL_44 nc_44_23 VGND sky130_fd_pr__nfet_01v8 w=0.42 l=0.17
XB44_24 VGND WL_44 nc_44_24 VGND sky130_fd_pr__nfet_01v8 w=0.42 l=0.17
XB44_25 VGND WL_44 BLN_25 VGND sky130_fd_pr__nfet_01v8 w=0.42 l=0.17
XB44_26 VGND WL_44 BLP_26 VGND sky130_fd_pr__nfet_01v8 w=0.42 l=0.17
XB44_27 VGND WL_44 nc_44_27 VGND sky130_fd_pr__nfet_01v8 w=0.42 l=0.17
XB44_28 VGND WL_44 nc_44_28 VGND sky130_fd_pr__nfet_01v8 w=0.42 l=0.17
XB44_29 VGND WL_44 BLP_29 VGND sky130_fd_pr__nfet_01v8 w=0.42 l=0.17
XB44_30 VGND WL_44 nc_44_30 VGND sky130_fd_pr__nfet_01v8 w=0.42 l=0.17
XB44_31 VGND WL_44 nc_44_31 VGND sky130_fd_pr__nfet_01v8 w=0.42 l=0.17
XB45_0 VGND WL_45 BLN_0 VGND sky130_fd_pr__nfet_01v8 w=0.42 l=0.17
XB45_1 VGND WL_45 BLN_1 VGND sky130_fd_pr__nfet_01v8 w=0.42 l=0.17
XB45_2 VGND WL_45 nc_45_2 VGND sky130_fd_pr__nfet_01v8 w=0.42 l=0.17
XB45_3 VGND WL_45 BLN_3 VGND sky130_fd_pr__nfet_01v8 w=0.42 l=0.17
XB45_4 VGND WL_45 nc_45_4 VGND sky130_fd_pr__nfet_01v8 w=0.42 l=0.17
XB45_5 VGND WL_45 nc_45_5 VGND sky130_fd_pr__nfet_01v8 w=0.42 l=0.17
XB45_6 VGND WL_45 nc_45_6 VGND sky130_fd_pr__nfet_01v8 w=0.42 l=0.17
XB45_7 VGND WL_45 nc_45_7 VGND sky130_fd_pr__nfet_01v8 w=0.42 l=0.17
XB45_8 VGND WL_45 BLP_8 VGND sky130_fd_pr__nfet_01v8 w=0.42 l=0.17
XB45_9 VGND WL_45 BLP_9 VGND sky130_fd_pr__nfet_01v8 w=0.42 l=0.17
XB45_10 VGND WL_45 BLP_10 VGND sky130_fd_pr__nfet_01v8 w=0.42 l=0.17
XB45_11 VGND WL_45 nc_45_11 VGND sky130_fd_pr__nfet_01v8 w=0.42 l=0.17
XB45_12 VGND WL_45 BLN_12 VGND sky130_fd_pr__nfet_01v8 w=0.42 l=0.17
XB45_13 VGND WL_45 BLN_13 VGND sky130_fd_pr__nfet_01v8 w=0.42 l=0.17
XB45_14 VGND WL_45 nc_45_14 VGND sky130_fd_pr__nfet_01v8 w=0.42 l=0.17
XB45_15 VGND WL_45 BLN_15 VGND sky130_fd_pr__nfet_01v8 w=0.42 l=0.17
XB45_16 VGND WL_45 BLP_16 VGND sky130_fd_pr__nfet_01v8 w=0.42 l=0.17
XB45_17 VGND WL_45 BLP_17 VGND sky130_fd_pr__nfet_01v8 w=0.42 l=0.17
XB45_18 VGND WL_45 nc_45_18 VGND sky130_fd_pr__nfet_01v8 w=0.42 l=0.17
XB45_19 VGND WL_45 nc_45_19 VGND sky130_fd_pr__nfet_01v8 w=0.42 l=0.17
XB45_20 VGND WL_45 BLP_20 VGND sky130_fd_pr__nfet_01v8 w=0.42 l=0.17
XB45_21 VGND WL_45 BLP_21 VGND sky130_fd_pr__nfet_01v8 w=0.42 l=0.17
XB45_22 VGND WL_45 nc_45_22 VGND sky130_fd_pr__nfet_01v8 w=0.42 l=0.17
XB45_23 VGND WL_45 BLN_23 VGND sky130_fd_pr__nfet_01v8 w=0.42 l=0.17
XB45_24 VGND WL_45 nc_45_24 VGND sky130_fd_pr__nfet_01v8 w=0.42 l=0.17
XB45_25 VGND WL_45 nc_45_25 VGND sky130_fd_pr__nfet_01v8 w=0.42 l=0.17
XB45_26 VGND WL_45 BLP_26 VGND sky130_fd_pr__nfet_01v8 w=0.42 l=0.17
XB45_27 VGND WL_45 nc_45_27 VGND sky130_fd_pr__nfet_01v8 w=0.42 l=0.17
XB45_28 VGND WL_45 nc_45_28 VGND sky130_fd_pr__nfet_01v8 w=0.42 l=0.17
XB45_29 VGND WL_45 BLP_29 VGND sky130_fd_pr__nfet_01v8 w=0.42 l=0.17
XB45_30 VGND WL_45 nc_45_30 VGND sky130_fd_pr__nfet_01v8 w=0.42 l=0.17
XB45_31 VGND WL_45 BLN_31 VGND sky130_fd_pr__nfet_01v8 w=0.42 l=0.17
XB46_0 VGND WL_46 BLN_0 VGND sky130_fd_pr__nfet_01v8 w=0.42 l=0.17
XB46_1 VGND WL_46 nc_46_1 VGND sky130_fd_pr__nfet_01v8 w=0.42 l=0.17
XB46_2 VGND WL_46 nc_46_2 VGND sky130_fd_pr__nfet_01v8 w=0.42 l=0.17
XB46_3 VGND WL_46 BLN_3 VGND sky130_fd_pr__nfet_01v8 w=0.42 l=0.17
XB46_4 VGND WL_46 nc_46_4 VGND sky130_fd_pr__nfet_01v8 w=0.42 l=0.17
XB46_5 VGND WL_46 BLP_5 VGND sky130_fd_pr__nfet_01v8 w=0.42 l=0.17
XB46_6 VGND WL_46 nc_46_6 VGND sky130_fd_pr__nfet_01v8 w=0.42 l=0.17
XB46_7 VGND WL_46 nc_46_7 VGND sky130_fd_pr__nfet_01v8 w=0.42 l=0.17
XB46_8 VGND WL_46 BLP_8 VGND sky130_fd_pr__nfet_01v8 w=0.42 l=0.17
XB46_9 VGND WL_46 nc_46_9 VGND sky130_fd_pr__nfet_01v8 w=0.42 l=0.17
XB46_10 VGND WL_46 nc_46_10 VGND sky130_fd_pr__nfet_01v8 w=0.42 l=0.17
XB46_11 VGND WL_46 nc_46_11 VGND sky130_fd_pr__nfet_01v8 w=0.42 l=0.17
XB46_12 VGND WL_46 nc_46_12 VGND sky130_fd_pr__nfet_01v8 w=0.42 l=0.17
XB46_13 VGND WL_46 nc_46_13 VGND sky130_fd_pr__nfet_01v8 w=0.42 l=0.17
XB46_14 VGND WL_46 nc_46_14 VGND sky130_fd_pr__nfet_01v8 w=0.42 l=0.17
XB46_15 VGND WL_46 nc_46_15 VGND sky130_fd_pr__nfet_01v8 w=0.42 l=0.17
XB46_16 VGND WL_46 BLP_16 VGND sky130_fd_pr__nfet_01v8 w=0.42 l=0.17
XB46_17 VGND WL_46 nc_46_17 VGND sky130_fd_pr__nfet_01v8 w=0.42 l=0.17
XB46_18 VGND WL_46 BLN_18 VGND sky130_fd_pr__nfet_01v8 w=0.42 l=0.17
XB46_19 VGND WL_46 nc_46_19 VGND sky130_fd_pr__nfet_01v8 w=0.42 l=0.17
XB46_20 VGND WL_46 BLP_20 VGND sky130_fd_pr__nfet_01v8 w=0.42 l=0.17
XB46_21 VGND WL_46 BLN_21 VGND sky130_fd_pr__nfet_01v8 w=0.42 l=0.17
XB46_22 VGND WL_46 BLP_22 VGND sky130_fd_pr__nfet_01v8 w=0.42 l=0.17
XB46_23 VGND WL_46 BLP_23 VGND sky130_fd_pr__nfet_01v8 w=0.42 l=0.17
XB46_24 VGND WL_46 BLP_24 VGND sky130_fd_pr__nfet_01v8 w=0.42 l=0.17
XB46_25 VGND WL_46 BLP_25 VGND sky130_fd_pr__nfet_01v8 w=0.42 l=0.17
XB46_26 VGND WL_46 nc_46_26 VGND sky130_fd_pr__nfet_01v8 w=0.42 l=0.17
XB46_27 VGND WL_46 nc_46_27 VGND sky130_fd_pr__nfet_01v8 w=0.42 l=0.17
XB46_28 VGND WL_46 nc_46_28 VGND sky130_fd_pr__nfet_01v8 w=0.42 l=0.17
XB46_29 VGND WL_46 BLN_29 VGND sky130_fd_pr__nfet_01v8 w=0.42 l=0.17
XB46_30 VGND WL_46 nc_46_30 VGND sky130_fd_pr__nfet_01v8 w=0.42 l=0.17
XB46_31 VGND WL_46 BLN_31 VGND sky130_fd_pr__nfet_01v8 w=0.42 l=0.17
XB47_0 VGND WL_47 BLN_0 VGND sky130_fd_pr__nfet_01v8 w=0.42 l=0.17
XB47_1 VGND WL_47 BLN_1 VGND sky130_fd_pr__nfet_01v8 w=0.42 l=0.17
XB47_2 VGND WL_47 nc_47_2 VGND sky130_fd_pr__nfet_01v8 w=0.42 l=0.17
XB47_3 VGND WL_47 BLP_3 VGND sky130_fd_pr__nfet_01v8 w=0.42 l=0.17
XB47_4 VGND WL_47 nc_47_4 VGND sky130_fd_pr__nfet_01v8 w=0.42 l=0.17
XB47_5 VGND WL_47 BLP_5 VGND sky130_fd_pr__nfet_01v8 w=0.42 l=0.17
XB47_6 VGND WL_47 BLN_6 VGND sky130_fd_pr__nfet_01v8 w=0.42 l=0.17
XB47_7 VGND WL_47 nc_47_7 VGND sky130_fd_pr__nfet_01v8 w=0.42 l=0.17
XB47_8 VGND WL_47 BLN_8 VGND sky130_fd_pr__nfet_01v8 w=0.42 l=0.17
XB47_9 VGND WL_47 nc_47_9 VGND sky130_fd_pr__nfet_01v8 w=0.42 l=0.17
XB47_10 VGND WL_47 BLP_10 VGND sky130_fd_pr__nfet_01v8 w=0.42 l=0.17
XB47_11 VGND WL_47 BLN_11 VGND sky130_fd_pr__nfet_01v8 w=0.42 l=0.17
XB47_12 VGND WL_47 nc_47_12 VGND sky130_fd_pr__nfet_01v8 w=0.42 l=0.17
XB47_13 VGND WL_47 BLN_13 VGND sky130_fd_pr__nfet_01v8 w=0.42 l=0.17
XB47_14 VGND WL_47 BLN_14 VGND sky130_fd_pr__nfet_01v8 w=0.42 l=0.17
XB47_15 VGND WL_47 BLN_15 VGND sky130_fd_pr__nfet_01v8 w=0.42 l=0.17
XB47_16 VGND WL_47 BLN_16 VGND sky130_fd_pr__nfet_01v8 w=0.42 l=0.17
XB47_17 VGND WL_47 BLP_17 VGND sky130_fd_pr__nfet_01v8 w=0.42 l=0.17
XB47_18 VGND WL_47 BLN_18 VGND sky130_fd_pr__nfet_01v8 w=0.42 l=0.17
XB47_19 VGND WL_47 nc_47_19 VGND sky130_fd_pr__nfet_01v8 w=0.42 l=0.17
XB47_20 VGND WL_47 BLP_20 VGND sky130_fd_pr__nfet_01v8 w=0.42 l=0.17
XB47_21 VGND WL_47 nc_47_21 VGND sky130_fd_pr__nfet_01v8 w=0.42 l=0.17
XB47_22 VGND WL_47 BLP_22 VGND sky130_fd_pr__nfet_01v8 w=0.42 l=0.17
XB47_23 VGND WL_47 nc_47_23 VGND sky130_fd_pr__nfet_01v8 w=0.42 l=0.17
XB47_24 VGND WL_47 BLP_24 VGND sky130_fd_pr__nfet_01v8 w=0.42 l=0.17
XB47_25 VGND WL_47 BLP_25 VGND sky130_fd_pr__nfet_01v8 w=0.42 l=0.17
XB47_26 VGND WL_47 nc_47_26 VGND sky130_fd_pr__nfet_01v8 w=0.42 l=0.17
XB47_27 VGND WL_47 nc_47_27 VGND sky130_fd_pr__nfet_01v8 w=0.42 l=0.17
XB47_28 VGND WL_47 nc_47_28 VGND sky130_fd_pr__nfet_01v8 w=0.42 l=0.17
XB47_29 VGND WL_47 nc_47_29 VGND sky130_fd_pr__nfet_01v8 w=0.42 l=0.17
XB47_30 VGND WL_47 nc_47_30 VGND sky130_fd_pr__nfet_01v8 w=0.42 l=0.17
XB47_31 VGND WL_47 BLP_31 VGND sky130_fd_pr__nfet_01v8 w=0.42 l=0.17
XB48_0 VGND WL_48 BLN_0 VGND sky130_fd_pr__nfet_01v8 w=0.42 l=0.17
XB48_1 VGND WL_48 BLN_1 VGND sky130_fd_pr__nfet_01v8 w=0.42 l=0.17
XB48_2 VGND WL_48 BLP_2 VGND sky130_fd_pr__nfet_01v8 w=0.42 l=0.17
XB48_3 VGND WL_48 nc_48_3 VGND sky130_fd_pr__nfet_01v8 w=0.42 l=0.17
XB48_4 VGND WL_48 BLN_4 VGND sky130_fd_pr__nfet_01v8 w=0.42 l=0.17
XB48_5 VGND WL_48 nc_48_5 VGND sky130_fd_pr__nfet_01v8 w=0.42 l=0.17
XB48_6 VGND WL_48 BLN_6 VGND sky130_fd_pr__nfet_01v8 w=0.42 l=0.17
XB48_7 VGND WL_48 nc_48_7 VGND sky130_fd_pr__nfet_01v8 w=0.42 l=0.17
XB48_8 VGND WL_48 nc_48_8 VGND sky130_fd_pr__nfet_01v8 w=0.42 l=0.17
XB48_9 VGND WL_48 nc_48_9 VGND sky130_fd_pr__nfet_01v8 w=0.42 l=0.17
XB48_10 VGND WL_48 BLN_10 VGND sky130_fd_pr__nfet_01v8 w=0.42 l=0.17
XB48_11 VGND WL_48 nc_48_11 VGND sky130_fd_pr__nfet_01v8 w=0.42 l=0.17
XB48_12 VGND WL_48 BLP_12 VGND sky130_fd_pr__nfet_01v8 w=0.42 l=0.17
XB48_13 VGND WL_48 BLN_13 VGND sky130_fd_pr__nfet_01v8 w=0.42 l=0.17
XB48_14 VGND WL_48 nc_48_14 VGND sky130_fd_pr__nfet_01v8 w=0.42 l=0.17
XB48_15 VGND WL_48 nc_48_15 VGND sky130_fd_pr__nfet_01v8 w=0.42 l=0.17
XB48_16 VGND WL_48 nc_48_16 VGND sky130_fd_pr__nfet_01v8 w=0.42 l=0.17
XB48_17 VGND WL_48 nc_48_17 VGND sky130_fd_pr__nfet_01v8 w=0.42 l=0.17
XB48_18 VGND WL_48 nc_48_18 VGND sky130_fd_pr__nfet_01v8 w=0.42 l=0.17
XB48_19 VGND WL_48 nc_48_19 VGND sky130_fd_pr__nfet_01v8 w=0.42 l=0.17
XB48_20 VGND WL_48 nc_48_20 VGND sky130_fd_pr__nfet_01v8 w=0.42 l=0.17
XB48_21 VGND WL_48 nc_48_21 VGND sky130_fd_pr__nfet_01v8 w=0.42 l=0.17
XB48_22 VGND WL_48 BLP_22 VGND sky130_fd_pr__nfet_01v8 w=0.42 l=0.17
XB48_23 VGND WL_48 nc_48_23 VGND sky130_fd_pr__nfet_01v8 w=0.42 l=0.17
XB48_24 VGND WL_48 nc_48_24 VGND sky130_fd_pr__nfet_01v8 w=0.42 l=0.17
XB48_25 VGND WL_48 BLN_25 VGND sky130_fd_pr__nfet_01v8 w=0.42 l=0.17
XB48_26 VGND WL_48 nc_48_26 VGND sky130_fd_pr__nfet_01v8 w=0.42 l=0.17
XB48_27 VGND WL_48 nc_48_27 VGND sky130_fd_pr__nfet_01v8 w=0.42 l=0.17
XB48_28 VGND WL_48 nc_48_28 VGND sky130_fd_pr__nfet_01v8 w=0.42 l=0.17
XB48_29 VGND WL_48 BLN_29 VGND sky130_fd_pr__nfet_01v8 w=0.42 l=0.17
XB48_30 VGND WL_48 nc_48_30 VGND sky130_fd_pr__nfet_01v8 w=0.42 l=0.17
XB48_31 VGND WL_48 nc_48_31 VGND sky130_fd_pr__nfet_01v8 w=0.42 l=0.17
XB49_0 VGND WL_49 BLP_0 VGND sky130_fd_pr__nfet_01v8 w=0.42 l=0.17
XB49_1 VGND WL_49 nc_49_1 VGND sky130_fd_pr__nfet_01v8 w=0.42 l=0.17
XB49_2 VGND WL_49 BLN_2 VGND sky130_fd_pr__nfet_01v8 w=0.42 l=0.17
XB49_3 VGND WL_49 nc_49_3 VGND sky130_fd_pr__nfet_01v8 w=0.42 l=0.17
XB49_4 VGND WL_49 nc_49_4 VGND sky130_fd_pr__nfet_01v8 w=0.42 l=0.17
XB49_5 VGND WL_49 BLP_5 VGND sky130_fd_pr__nfet_01v8 w=0.42 l=0.17
XB49_6 VGND WL_49 nc_49_6 VGND sky130_fd_pr__nfet_01v8 w=0.42 l=0.17
XB49_7 VGND WL_49 nc_49_7 VGND sky130_fd_pr__nfet_01v8 w=0.42 l=0.17
XB49_8 VGND WL_49 BLP_8 VGND sky130_fd_pr__nfet_01v8 w=0.42 l=0.17
XB49_9 VGND WL_49 nc_49_9 VGND sky130_fd_pr__nfet_01v8 w=0.42 l=0.17
XB49_10 VGND WL_49 BLN_10 VGND sky130_fd_pr__nfet_01v8 w=0.42 l=0.17
XB49_11 VGND WL_49 nc_49_11 VGND sky130_fd_pr__nfet_01v8 w=0.42 l=0.17
XB49_12 VGND WL_49 BLN_12 VGND sky130_fd_pr__nfet_01v8 w=0.42 l=0.17
XB49_13 VGND WL_49 nc_49_13 VGND sky130_fd_pr__nfet_01v8 w=0.42 l=0.17
XB49_14 VGND WL_49 BLP_14 VGND sky130_fd_pr__nfet_01v8 w=0.42 l=0.17
XB49_15 VGND WL_49 BLP_15 VGND sky130_fd_pr__nfet_01v8 w=0.42 l=0.17
XB49_16 VGND WL_49 BLN_16 VGND sky130_fd_pr__nfet_01v8 w=0.42 l=0.17
XB49_17 VGND WL_49 BLP_17 VGND sky130_fd_pr__nfet_01v8 w=0.42 l=0.17
XB49_18 VGND WL_49 nc_49_18 VGND sky130_fd_pr__nfet_01v8 w=0.42 l=0.17
XB49_19 VGND WL_49 BLP_19 VGND sky130_fd_pr__nfet_01v8 w=0.42 l=0.17
XB49_20 VGND WL_49 BLP_20 VGND sky130_fd_pr__nfet_01v8 w=0.42 l=0.17
XB49_21 VGND WL_49 nc_49_21 VGND sky130_fd_pr__nfet_01v8 w=0.42 l=0.17
XB49_22 VGND WL_49 nc_49_22 VGND sky130_fd_pr__nfet_01v8 w=0.42 l=0.17
XB49_23 VGND WL_49 nc_49_23 VGND sky130_fd_pr__nfet_01v8 w=0.42 l=0.17
XB49_24 VGND WL_49 nc_49_24 VGND sky130_fd_pr__nfet_01v8 w=0.42 l=0.17
XB49_25 VGND WL_49 BLP_25 VGND sky130_fd_pr__nfet_01v8 w=0.42 l=0.17
XB49_26 VGND WL_49 BLP_26 VGND sky130_fd_pr__nfet_01v8 w=0.42 l=0.17
XB49_27 VGND WL_49 BLP_27 VGND sky130_fd_pr__nfet_01v8 w=0.42 l=0.17
XB49_28 VGND WL_49 nc_49_28 VGND sky130_fd_pr__nfet_01v8 w=0.42 l=0.17
XB49_29 VGND WL_49 BLN_29 VGND sky130_fd_pr__nfet_01v8 w=0.42 l=0.17
XB49_30 VGND WL_49 nc_49_30 VGND sky130_fd_pr__nfet_01v8 w=0.42 l=0.17
XB49_31 VGND WL_49 nc_49_31 VGND sky130_fd_pr__nfet_01v8 w=0.42 l=0.17
XB50_0 VGND WL_50 nc_50_0 VGND sky130_fd_pr__nfet_01v8 w=0.42 l=0.17
XB50_1 VGND WL_50 BLP_1 VGND sky130_fd_pr__nfet_01v8 w=0.42 l=0.17
XB50_2 VGND WL_50 BLP_2 VGND sky130_fd_pr__nfet_01v8 w=0.42 l=0.17
XB50_3 VGND WL_50 BLN_3 VGND sky130_fd_pr__nfet_01v8 w=0.42 l=0.17
XB50_4 VGND WL_50 BLN_4 VGND sky130_fd_pr__nfet_01v8 w=0.42 l=0.17
XB50_5 VGND WL_50 BLN_5 VGND sky130_fd_pr__nfet_01v8 w=0.42 l=0.17
XB50_6 VGND WL_50 nc_50_6 VGND sky130_fd_pr__nfet_01v8 w=0.42 l=0.17
XB50_7 VGND WL_50 nc_50_7 VGND sky130_fd_pr__nfet_01v8 w=0.42 l=0.17
XB50_8 VGND WL_50 BLP_8 VGND sky130_fd_pr__nfet_01v8 w=0.42 l=0.17
XB50_9 VGND WL_50 nc_50_9 VGND sky130_fd_pr__nfet_01v8 w=0.42 l=0.17
XB50_10 VGND WL_50 nc_50_10 VGND sky130_fd_pr__nfet_01v8 w=0.42 l=0.17
XB50_11 VGND WL_50 nc_50_11 VGND sky130_fd_pr__nfet_01v8 w=0.42 l=0.17
XB50_12 VGND WL_50 BLP_12 VGND sky130_fd_pr__nfet_01v8 w=0.42 l=0.17
XB50_13 VGND WL_50 nc_50_13 VGND sky130_fd_pr__nfet_01v8 w=0.42 l=0.17
XB50_14 VGND WL_50 BLP_14 VGND sky130_fd_pr__nfet_01v8 w=0.42 l=0.17
XB50_15 VGND WL_50 BLP_15 VGND sky130_fd_pr__nfet_01v8 w=0.42 l=0.17
XB50_16 VGND WL_50 BLN_16 VGND sky130_fd_pr__nfet_01v8 w=0.42 l=0.17
XB50_17 VGND WL_50 nc_50_17 VGND sky130_fd_pr__nfet_01v8 w=0.42 l=0.17
XB50_18 VGND WL_50 BLN_18 VGND sky130_fd_pr__nfet_01v8 w=0.42 l=0.17
XB50_19 VGND WL_50 BLP_19 VGND sky130_fd_pr__nfet_01v8 w=0.42 l=0.17
XB50_20 VGND WL_50 BLP_20 VGND sky130_fd_pr__nfet_01v8 w=0.42 l=0.17
XB50_21 VGND WL_50 nc_50_21 VGND sky130_fd_pr__nfet_01v8 w=0.42 l=0.17
XB50_22 VGND WL_50 BLP_22 VGND sky130_fd_pr__nfet_01v8 w=0.42 l=0.17
XB50_23 VGND WL_50 nc_50_23 VGND sky130_fd_pr__nfet_01v8 w=0.42 l=0.17
XB50_24 VGND WL_50 nc_50_24 VGND sky130_fd_pr__nfet_01v8 w=0.42 l=0.17
XB50_25 VGND WL_50 BLN_25 VGND sky130_fd_pr__nfet_01v8 w=0.42 l=0.17
XB50_26 VGND WL_50 nc_50_26 VGND sky130_fd_pr__nfet_01v8 w=0.42 l=0.17
XB50_27 VGND WL_50 nc_50_27 VGND sky130_fd_pr__nfet_01v8 w=0.42 l=0.17
XB50_28 VGND WL_50 BLP_28 VGND sky130_fd_pr__nfet_01v8 w=0.42 l=0.17
XB50_29 VGND WL_50 BLP_29 VGND sky130_fd_pr__nfet_01v8 w=0.42 l=0.17
XB50_30 VGND WL_50 nc_50_30 VGND sky130_fd_pr__nfet_01v8 w=0.42 l=0.17
XB50_31 VGND WL_50 nc_50_31 VGND sky130_fd_pr__nfet_01v8 w=0.42 l=0.17
XB51_0 VGND WL_51 BLN_0 VGND sky130_fd_pr__nfet_01v8 w=0.42 l=0.17
XB51_1 VGND WL_51 BLN_1 VGND sky130_fd_pr__nfet_01v8 w=0.42 l=0.17
XB51_2 VGND WL_51 nc_51_2 VGND sky130_fd_pr__nfet_01v8 w=0.42 l=0.17
XB51_3 VGND WL_51 nc_51_3 VGND sky130_fd_pr__nfet_01v8 w=0.42 l=0.17
XB51_4 VGND WL_51 BLN_4 VGND sky130_fd_pr__nfet_01v8 w=0.42 l=0.17
XB51_5 VGND WL_51 BLP_5 VGND sky130_fd_pr__nfet_01v8 w=0.42 l=0.17
XB51_6 VGND WL_51 nc_51_6 VGND sky130_fd_pr__nfet_01v8 w=0.42 l=0.17
XB51_7 VGND WL_51 BLN_7 VGND sky130_fd_pr__nfet_01v8 w=0.42 l=0.17
XB51_8 VGND WL_51 BLP_8 VGND sky130_fd_pr__nfet_01v8 w=0.42 l=0.17
XB51_9 VGND WL_51 BLN_9 VGND sky130_fd_pr__nfet_01v8 w=0.42 l=0.17
XB51_10 VGND WL_51 BLP_10 VGND sky130_fd_pr__nfet_01v8 w=0.42 l=0.17
XB51_11 VGND WL_51 BLN_11 VGND sky130_fd_pr__nfet_01v8 w=0.42 l=0.17
XB51_12 VGND WL_51 nc_51_12 VGND sky130_fd_pr__nfet_01v8 w=0.42 l=0.17
XB51_13 VGND WL_51 BLP_13 VGND sky130_fd_pr__nfet_01v8 w=0.42 l=0.17
XB51_14 VGND WL_51 nc_51_14 VGND sky130_fd_pr__nfet_01v8 w=0.42 l=0.17
XB51_15 VGND WL_51 nc_51_15 VGND sky130_fd_pr__nfet_01v8 w=0.42 l=0.17
XB51_16 VGND WL_51 nc_51_16 VGND sky130_fd_pr__nfet_01v8 w=0.42 l=0.17
XB51_17 VGND WL_51 BLN_17 VGND sky130_fd_pr__nfet_01v8 w=0.42 l=0.17
XB51_18 VGND WL_51 nc_51_18 VGND sky130_fd_pr__nfet_01v8 w=0.42 l=0.17
XB51_19 VGND WL_51 BLN_19 VGND sky130_fd_pr__nfet_01v8 w=0.42 l=0.17
XB51_20 VGND WL_51 BLN_20 VGND sky130_fd_pr__nfet_01v8 w=0.42 l=0.17
XB51_21 VGND WL_51 BLP_21 VGND sky130_fd_pr__nfet_01v8 w=0.42 l=0.17
XB51_22 VGND WL_51 nc_51_22 VGND sky130_fd_pr__nfet_01v8 w=0.42 l=0.17
XB51_23 VGND WL_51 BLP_23 VGND sky130_fd_pr__nfet_01v8 w=0.42 l=0.17
XB51_24 VGND WL_51 nc_51_24 VGND sky130_fd_pr__nfet_01v8 w=0.42 l=0.17
XB51_25 VGND WL_51 nc_51_25 VGND sky130_fd_pr__nfet_01v8 w=0.42 l=0.17
XB51_26 VGND WL_51 BLP_26 VGND sky130_fd_pr__nfet_01v8 w=0.42 l=0.17
XB51_27 VGND WL_51 nc_51_27 VGND sky130_fd_pr__nfet_01v8 w=0.42 l=0.17
XB51_28 VGND WL_51 nc_51_28 VGND sky130_fd_pr__nfet_01v8 w=0.42 l=0.17
XB51_29 VGND WL_51 BLP_29 VGND sky130_fd_pr__nfet_01v8 w=0.42 l=0.17
XB51_30 VGND WL_51 BLP_30 VGND sky130_fd_pr__nfet_01v8 w=0.42 l=0.17
XB51_31 VGND WL_51 nc_51_31 VGND sky130_fd_pr__nfet_01v8 w=0.42 l=0.17
XB52_0 VGND WL_52 BLP_0 VGND sky130_fd_pr__nfet_01v8 w=0.42 l=0.17
XB52_1 VGND WL_52 BLN_1 VGND sky130_fd_pr__nfet_01v8 w=0.42 l=0.17
XB52_2 VGND WL_52 BLN_2 VGND sky130_fd_pr__nfet_01v8 w=0.42 l=0.17
XB52_3 VGND WL_52 nc_52_3 VGND sky130_fd_pr__nfet_01v8 w=0.42 l=0.17
XB52_4 VGND WL_52 nc_52_4 VGND sky130_fd_pr__nfet_01v8 w=0.42 l=0.17
XB52_5 VGND WL_52 BLN_5 VGND sky130_fd_pr__nfet_01v8 w=0.42 l=0.17
XB52_6 VGND WL_52 nc_52_6 VGND sky130_fd_pr__nfet_01v8 w=0.42 l=0.17
XB52_7 VGND WL_52 nc_52_7 VGND sky130_fd_pr__nfet_01v8 w=0.42 l=0.17
XB52_8 VGND WL_52 BLN_8 VGND sky130_fd_pr__nfet_01v8 w=0.42 l=0.17
XB52_9 VGND WL_52 BLN_9 VGND sky130_fd_pr__nfet_01v8 w=0.42 l=0.17
XB52_10 VGND WL_52 BLP_10 VGND sky130_fd_pr__nfet_01v8 w=0.42 l=0.17
XB52_11 VGND WL_52 nc_52_11 VGND sky130_fd_pr__nfet_01v8 w=0.42 l=0.17
XB52_12 VGND WL_52 BLN_12 VGND sky130_fd_pr__nfet_01v8 w=0.42 l=0.17
XB52_13 VGND WL_52 nc_52_13 VGND sky130_fd_pr__nfet_01v8 w=0.42 l=0.17
XB52_14 VGND WL_52 BLN_14 VGND sky130_fd_pr__nfet_01v8 w=0.42 l=0.17
XB52_15 VGND WL_52 nc_52_15 VGND sky130_fd_pr__nfet_01v8 w=0.42 l=0.17
XB52_16 VGND WL_52 BLP_16 VGND sky130_fd_pr__nfet_01v8 w=0.42 l=0.17
XB52_17 VGND WL_52 nc_52_17 VGND sky130_fd_pr__nfet_01v8 w=0.42 l=0.17
XB52_18 VGND WL_52 BLN_18 VGND sky130_fd_pr__nfet_01v8 w=0.42 l=0.17
XB52_19 VGND WL_52 BLP_19 VGND sky130_fd_pr__nfet_01v8 w=0.42 l=0.17
XB52_20 VGND WL_52 BLP_20 VGND sky130_fd_pr__nfet_01v8 w=0.42 l=0.17
XB52_21 VGND WL_52 nc_52_21 VGND sky130_fd_pr__nfet_01v8 w=0.42 l=0.17
XB52_22 VGND WL_52 BLN_22 VGND sky130_fd_pr__nfet_01v8 w=0.42 l=0.17
XB52_23 VGND WL_52 BLN_23 VGND sky130_fd_pr__nfet_01v8 w=0.42 l=0.17
XB52_24 VGND WL_52 nc_52_24 VGND sky130_fd_pr__nfet_01v8 w=0.42 l=0.17
XB52_25 VGND WL_52 nc_52_25 VGND sky130_fd_pr__nfet_01v8 w=0.42 l=0.17
XB52_26 VGND WL_52 BLP_26 VGND sky130_fd_pr__nfet_01v8 w=0.42 l=0.17
XB52_27 VGND WL_52 BLP_27 VGND sky130_fd_pr__nfet_01v8 w=0.42 l=0.17
XB52_28 VGND WL_52 nc_52_28 VGND sky130_fd_pr__nfet_01v8 w=0.42 l=0.17
XB52_29 VGND WL_52 BLP_29 VGND sky130_fd_pr__nfet_01v8 w=0.42 l=0.17
XB52_30 VGND WL_52 BLN_30 VGND sky130_fd_pr__nfet_01v8 w=0.42 l=0.17
XB52_31 VGND WL_52 BLN_31 VGND sky130_fd_pr__nfet_01v8 w=0.42 l=0.17
XB53_0 VGND WL_53 BLP_0 VGND sky130_fd_pr__nfet_01v8 w=0.42 l=0.17
XB53_1 VGND WL_53 nc_53_1 VGND sky130_fd_pr__nfet_01v8 w=0.42 l=0.17
XB53_2 VGND WL_53 nc_53_2 VGND sky130_fd_pr__nfet_01v8 w=0.42 l=0.17
XB53_3 VGND WL_53 nc_53_3 VGND sky130_fd_pr__nfet_01v8 w=0.42 l=0.17
XB53_4 VGND WL_53 nc_53_4 VGND sky130_fd_pr__nfet_01v8 w=0.42 l=0.17
XB53_5 VGND WL_53 BLP_5 VGND sky130_fd_pr__nfet_01v8 w=0.42 l=0.17
XB53_6 VGND WL_53 nc_53_6 VGND sky130_fd_pr__nfet_01v8 w=0.42 l=0.17
XB53_7 VGND WL_53 BLP_7 VGND sky130_fd_pr__nfet_01v8 w=0.42 l=0.17
XB53_8 VGND WL_53 BLP_8 VGND sky130_fd_pr__nfet_01v8 w=0.42 l=0.17
XB53_9 VGND WL_53 BLP_9 VGND sky130_fd_pr__nfet_01v8 w=0.42 l=0.17
XB53_10 VGND WL_53 nc_53_10 VGND sky130_fd_pr__nfet_01v8 w=0.42 l=0.17
XB53_11 VGND WL_53 nc_53_11 VGND sky130_fd_pr__nfet_01v8 w=0.42 l=0.17
XB53_12 VGND WL_53 BLN_12 VGND sky130_fd_pr__nfet_01v8 w=0.42 l=0.17
XB53_13 VGND WL_53 BLP_13 VGND sky130_fd_pr__nfet_01v8 w=0.42 l=0.17
XB53_14 VGND WL_53 BLP_14 VGND sky130_fd_pr__nfet_01v8 w=0.42 l=0.17
XB53_15 VGND WL_53 BLN_15 VGND sky130_fd_pr__nfet_01v8 w=0.42 l=0.17
XB53_16 VGND WL_53 nc_53_16 VGND sky130_fd_pr__nfet_01v8 w=0.42 l=0.17
XB53_17 VGND WL_53 nc_53_17 VGND sky130_fd_pr__nfet_01v8 w=0.42 l=0.17
XB53_18 VGND WL_53 nc_53_18 VGND sky130_fd_pr__nfet_01v8 w=0.42 l=0.17
XB53_19 VGND WL_53 nc_53_19 VGND sky130_fd_pr__nfet_01v8 w=0.42 l=0.17
XB53_20 VGND WL_53 BLP_20 VGND sky130_fd_pr__nfet_01v8 w=0.42 l=0.17
XB53_21 VGND WL_53 BLN_21 VGND sky130_fd_pr__nfet_01v8 w=0.42 l=0.17
XB53_22 VGND WL_53 BLN_22 VGND sky130_fd_pr__nfet_01v8 w=0.42 l=0.17
XB53_23 VGND WL_53 BLN_23 VGND sky130_fd_pr__nfet_01v8 w=0.42 l=0.17
XB53_24 VGND WL_53 nc_53_24 VGND sky130_fd_pr__nfet_01v8 w=0.42 l=0.17
XB53_25 VGND WL_53 nc_53_25 VGND sky130_fd_pr__nfet_01v8 w=0.42 l=0.17
XB53_26 VGND WL_53 nc_53_26 VGND sky130_fd_pr__nfet_01v8 w=0.42 l=0.17
XB53_27 VGND WL_53 BLP_27 VGND sky130_fd_pr__nfet_01v8 w=0.42 l=0.17
XB53_28 VGND WL_53 nc_53_28 VGND sky130_fd_pr__nfet_01v8 w=0.42 l=0.17
XB53_29 VGND WL_53 BLN_29 VGND sky130_fd_pr__nfet_01v8 w=0.42 l=0.17
XB53_30 VGND WL_53 BLP_30 VGND sky130_fd_pr__nfet_01v8 w=0.42 l=0.17
XB53_31 VGND WL_53 nc_53_31 VGND sky130_fd_pr__nfet_01v8 w=0.42 l=0.17
XB54_0 VGND WL_54 BLN_0 VGND sky130_fd_pr__nfet_01v8 w=0.42 l=0.17
XB54_1 VGND WL_54 nc_54_1 VGND sky130_fd_pr__nfet_01v8 w=0.42 l=0.17
XB54_2 VGND WL_54 nc_54_2 VGND sky130_fd_pr__nfet_01v8 w=0.42 l=0.17
XB54_3 VGND WL_54 BLP_3 VGND sky130_fd_pr__nfet_01v8 w=0.42 l=0.17
XB54_4 VGND WL_54 nc_54_4 VGND sky130_fd_pr__nfet_01v8 w=0.42 l=0.17
XB54_5 VGND WL_54 nc_54_5 VGND sky130_fd_pr__nfet_01v8 w=0.42 l=0.17
XB54_6 VGND WL_54 BLN_6 VGND sky130_fd_pr__nfet_01v8 w=0.42 l=0.17
XB54_7 VGND WL_54 BLP_7 VGND sky130_fd_pr__nfet_01v8 w=0.42 l=0.17
XB54_8 VGND WL_54 BLP_8 VGND sky130_fd_pr__nfet_01v8 w=0.42 l=0.17
XB54_9 VGND WL_54 BLP_9 VGND sky130_fd_pr__nfet_01v8 w=0.42 l=0.17
XB54_10 VGND WL_54 BLN_10 VGND sky130_fd_pr__nfet_01v8 w=0.42 l=0.17
XB54_11 VGND WL_54 nc_54_11 VGND sky130_fd_pr__nfet_01v8 w=0.42 l=0.17
XB54_12 VGND WL_54 nc_54_12 VGND sky130_fd_pr__nfet_01v8 w=0.42 l=0.17
XB54_13 VGND WL_54 nc_54_13 VGND sky130_fd_pr__nfet_01v8 w=0.42 l=0.17
XB54_14 VGND WL_54 nc_54_14 VGND sky130_fd_pr__nfet_01v8 w=0.42 l=0.17
XB54_15 VGND WL_54 BLP_15 VGND sky130_fd_pr__nfet_01v8 w=0.42 l=0.17
XB54_16 VGND WL_54 BLP_16 VGND sky130_fd_pr__nfet_01v8 w=0.42 l=0.17
XB54_17 VGND WL_54 nc_54_17 VGND sky130_fd_pr__nfet_01v8 w=0.42 l=0.17
XB54_18 VGND WL_54 nc_54_18 VGND sky130_fd_pr__nfet_01v8 w=0.42 l=0.17
XB54_19 VGND WL_54 nc_54_19 VGND sky130_fd_pr__nfet_01v8 w=0.42 l=0.17
XB54_20 VGND WL_54 BLP_20 VGND sky130_fd_pr__nfet_01v8 w=0.42 l=0.17
XB54_21 VGND WL_54 nc_54_21 VGND sky130_fd_pr__nfet_01v8 w=0.42 l=0.17
XB54_22 VGND WL_54 nc_54_22 VGND sky130_fd_pr__nfet_01v8 w=0.42 l=0.17
XB54_23 VGND WL_54 nc_54_23 VGND sky130_fd_pr__nfet_01v8 w=0.42 l=0.17
XB54_24 VGND WL_54 nc_54_24 VGND sky130_fd_pr__nfet_01v8 w=0.42 l=0.17
XB54_25 VGND WL_54 BLP_25 VGND sky130_fd_pr__nfet_01v8 w=0.42 l=0.17
XB54_26 VGND WL_54 nc_54_26 VGND sky130_fd_pr__nfet_01v8 w=0.42 l=0.17
XB54_27 VGND WL_54 BLP_27 VGND sky130_fd_pr__nfet_01v8 w=0.42 l=0.17
XB54_28 VGND WL_54 BLP_28 VGND sky130_fd_pr__nfet_01v8 w=0.42 l=0.17
XB54_29 VGND WL_54 nc_54_29 VGND sky130_fd_pr__nfet_01v8 w=0.42 l=0.17
XB54_30 VGND WL_54 BLP_30 VGND sky130_fd_pr__nfet_01v8 w=0.42 l=0.17
XB54_31 VGND WL_54 nc_54_31 VGND sky130_fd_pr__nfet_01v8 w=0.42 l=0.17
XB55_0 VGND WL_55 nc_55_0 VGND sky130_fd_pr__nfet_01v8 w=0.42 l=0.17
XB55_1 VGND WL_55 nc_55_1 VGND sky130_fd_pr__nfet_01v8 w=0.42 l=0.17
XB55_2 VGND WL_55 BLN_2 VGND sky130_fd_pr__nfet_01v8 w=0.42 l=0.17
XB55_3 VGND WL_55 nc_55_3 VGND sky130_fd_pr__nfet_01v8 w=0.42 l=0.17
XB55_4 VGND WL_55 nc_55_4 VGND sky130_fd_pr__nfet_01v8 w=0.42 l=0.17
XB55_5 VGND WL_55 nc_55_5 VGND sky130_fd_pr__nfet_01v8 w=0.42 l=0.17
XB55_6 VGND WL_55 BLP_6 VGND sky130_fd_pr__nfet_01v8 w=0.42 l=0.17
XB55_7 VGND WL_55 nc_55_7 VGND sky130_fd_pr__nfet_01v8 w=0.42 l=0.17
XB55_8 VGND WL_55 nc_55_8 VGND sky130_fd_pr__nfet_01v8 w=0.42 l=0.17
XB55_9 VGND WL_55 nc_55_9 VGND sky130_fd_pr__nfet_01v8 w=0.42 l=0.17
XB55_10 VGND WL_55 BLP_10 VGND sky130_fd_pr__nfet_01v8 w=0.42 l=0.17
XB55_11 VGND WL_55 nc_55_11 VGND sky130_fd_pr__nfet_01v8 w=0.42 l=0.17
XB55_12 VGND WL_55 BLN_12 VGND sky130_fd_pr__nfet_01v8 w=0.42 l=0.17
XB55_13 VGND WL_55 BLP_13 VGND sky130_fd_pr__nfet_01v8 w=0.42 l=0.17
XB55_14 VGND WL_55 nc_55_14 VGND sky130_fd_pr__nfet_01v8 w=0.42 l=0.17
XB55_15 VGND WL_55 nc_55_15 VGND sky130_fd_pr__nfet_01v8 w=0.42 l=0.17
XB55_16 VGND WL_55 BLN_16 VGND sky130_fd_pr__nfet_01v8 w=0.42 l=0.17
XB55_17 VGND WL_55 nc_55_17 VGND sky130_fd_pr__nfet_01v8 w=0.42 l=0.17
XB55_18 VGND WL_55 BLP_18 VGND sky130_fd_pr__nfet_01v8 w=0.42 l=0.17
XB55_19 VGND WL_55 nc_55_19 VGND sky130_fd_pr__nfet_01v8 w=0.42 l=0.17
XB55_20 VGND WL_55 BLP_20 VGND sky130_fd_pr__nfet_01v8 w=0.42 l=0.17
XB55_21 VGND WL_55 nc_55_21 VGND sky130_fd_pr__nfet_01v8 w=0.42 l=0.17
XB55_22 VGND WL_55 BLN_22 VGND sky130_fd_pr__nfet_01v8 w=0.42 l=0.17
XB55_23 VGND WL_55 nc_55_23 VGND sky130_fd_pr__nfet_01v8 w=0.42 l=0.17
XB55_24 VGND WL_55 BLN_24 VGND sky130_fd_pr__nfet_01v8 w=0.42 l=0.17
XB55_25 VGND WL_55 nc_55_25 VGND sky130_fd_pr__nfet_01v8 w=0.42 l=0.17
XB55_26 VGND WL_55 nc_55_26 VGND sky130_fd_pr__nfet_01v8 w=0.42 l=0.17
XB55_27 VGND WL_55 BLN_27 VGND sky130_fd_pr__nfet_01v8 w=0.42 l=0.17
XB55_28 VGND WL_55 BLP_28 VGND sky130_fd_pr__nfet_01v8 w=0.42 l=0.17
XB55_29 VGND WL_55 nc_55_29 VGND sky130_fd_pr__nfet_01v8 w=0.42 l=0.17
XB55_30 VGND WL_55 BLP_30 VGND sky130_fd_pr__nfet_01v8 w=0.42 l=0.17
XB55_31 VGND WL_55 BLP_31 VGND sky130_fd_pr__nfet_01v8 w=0.42 l=0.17
XB56_0 VGND WL_56 nc_56_0 VGND sky130_fd_pr__nfet_01v8 w=0.42 l=0.17
XB56_1 VGND WL_56 nc_56_1 VGND sky130_fd_pr__nfet_01v8 w=0.42 l=0.17
XB56_2 VGND WL_56 BLP_2 VGND sky130_fd_pr__nfet_01v8 w=0.42 l=0.17
XB56_3 VGND WL_56 BLP_3 VGND sky130_fd_pr__nfet_01v8 w=0.42 l=0.17
XB56_4 VGND WL_56 nc_56_4 VGND sky130_fd_pr__nfet_01v8 w=0.42 l=0.17
XB56_5 VGND WL_56 nc_56_5 VGND sky130_fd_pr__nfet_01v8 w=0.42 l=0.17
XB56_6 VGND WL_56 nc_56_6 VGND sky130_fd_pr__nfet_01v8 w=0.42 l=0.17
XB56_7 VGND WL_56 BLN_7 VGND sky130_fd_pr__nfet_01v8 w=0.42 l=0.17
XB56_8 VGND WL_56 BLP_8 VGND sky130_fd_pr__nfet_01v8 w=0.42 l=0.17
XB56_9 VGND WL_56 BLP_9 VGND sky130_fd_pr__nfet_01v8 w=0.42 l=0.17
XB56_10 VGND WL_56 nc_56_10 VGND sky130_fd_pr__nfet_01v8 w=0.42 l=0.17
XB56_11 VGND WL_56 nc_56_11 VGND sky130_fd_pr__nfet_01v8 w=0.42 l=0.17
XB56_12 VGND WL_56 BLP_12 VGND sky130_fd_pr__nfet_01v8 w=0.42 l=0.17
XB56_13 VGND WL_56 nc_56_13 VGND sky130_fd_pr__nfet_01v8 w=0.42 l=0.17
XB56_14 VGND WL_56 nc_56_14 VGND sky130_fd_pr__nfet_01v8 w=0.42 l=0.17
XB56_15 VGND WL_56 BLN_15 VGND sky130_fd_pr__nfet_01v8 w=0.42 l=0.17
XB56_16 VGND WL_56 BLN_16 VGND sky130_fd_pr__nfet_01v8 w=0.42 l=0.17
XB56_17 VGND WL_56 BLP_17 VGND sky130_fd_pr__nfet_01v8 w=0.42 l=0.17
XB56_18 VGND WL_56 nc_56_18 VGND sky130_fd_pr__nfet_01v8 w=0.42 l=0.17
XB56_19 VGND WL_56 BLN_19 VGND sky130_fd_pr__nfet_01v8 w=0.42 l=0.17
XB56_20 VGND WL_56 nc_56_20 VGND sky130_fd_pr__nfet_01v8 w=0.42 l=0.17
XB56_21 VGND WL_56 nc_56_21 VGND sky130_fd_pr__nfet_01v8 w=0.42 l=0.17
XB56_22 VGND WL_56 nc_56_22 VGND sky130_fd_pr__nfet_01v8 w=0.42 l=0.17
XB56_23 VGND WL_56 nc_56_23 VGND sky130_fd_pr__nfet_01v8 w=0.42 l=0.17
XB56_24 VGND WL_56 BLP_24 VGND sky130_fd_pr__nfet_01v8 w=0.42 l=0.17
XB56_25 VGND WL_56 BLP_25 VGND sky130_fd_pr__nfet_01v8 w=0.42 l=0.17
XB56_26 VGND WL_56 nc_56_26 VGND sky130_fd_pr__nfet_01v8 w=0.42 l=0.17
XB56_27 VGND WL_56 nc_56_27 VGND sky130_fd_pr__nfet_01v8 w=0.42 l=0.17
XB56_28 VGND WL_56 nc_56_28 VGND sky130_fd_pr__nfet_01v8 w=0.42 l=0.17
XB56_29 VGND WL_56 BLN_29 VGND sky130_fd_pr__nfet_01v8 w=0.42 l=0.17
XB56_30 VGND WL_56 nc_56_30 VGND sky130_fd_pr__nfet_01v8 w=0.42 l=0.17
XB56_31 VGND WL_56 BLN_31 VGND sky130_fd_pr__nfet_01v8 w=0.42 l=0.17
XB57_0 VGND WL_57 BLP_0 VGND sky130_fd_pr__nfet_01v8 w=0.42 l=0.17
XB57_1 VGND WL_57 nc_57_1 VGND sky130_fd_pr__nfet_01v8 w=0.42 l=0.17
XB57_2 VGND WL_57 BLN_2 VGND sky130_fd_pr__nfet_01v8 w=0.42 l=0.17
XB57_3 VGND WL_57 BLN_3 VGND sky130_fd_pr__nfet_01v8 w=0.42 l=0.17
XB57_4 VGND WL_57 nc_57_4 VGND sky130_fd_pr__nfet_01v8 w=0.42 l=0.17
XB57_5 VGND WL_57 BLN_5 VGND sky130_fd_pr__nfet_01v8 w=0.42 l=0.17
XB57_6 VGND WL_57 nc_57_6 VGND sky130_fd_pr__nfet_01v8 w=0.42 l=0.17
XB57_7 VGND WL_57 BLP_7 VGND sky130_fd_pr__nfet_01v8 w=0.42 l=0.17
XB57_8 VGND WL_57 BLN_8 VGND sky130_fd_pr__nfet_01v8 w=0.42 l=0.17
XB57_9 VGND WL_57 nc_57_9 VGND sky130_fd_pr__nfet_01v8 w=0.42 l=0.17
XB57_10 VGND WL_57 BLN_10 VGND sky130_fd_pr__nfet_01v8 w=0.42 l=0.17
XB57_11 VGND WL_57 nc_57_11 VGND sky130_fd_pr__nfet_01v8 w=0.42 l=0.17
XB57_12 VGND WL_57 BLP_12 VGND sky130_fd_pr__nfet_01v8 w=0.42 l=0.17
XB57_13 VGND WL_57 BLP_13 VGND sky130_fd_pr__nfet_01v8 w=0.42 l=0.17
XB57_14 VGND WL_57 BLN_14 VGND sky130_fd_pr__nfet_01v8 w=0.42 l=0.17
XB57_15 VGND WL_57 nc_57_15 VGND sky130_fd_pr__nfet_01v8 w=0.42 l=0.17
XB57_16 VGND WL_57 BLP_16 VGND sky130_fd_pr__nfet_01v8 w=0.42 l=0.17
XB57_17 VGND WL_57 nc_57_17 VGND sky130_fd_pr__nfet_01v8 w=0.42 l=0.17
XB57_18 VGND WL_57 nc_57_18 VGND sky130_fd_pr__nfet_01v8 w=0.42 l=0.17
XB57_19 VGND WL_57 nc_57_19 VGND sky130_fd_pr__nfet_01v8 w=0.42 l=0.17
XB57_20 VGND WL_57 BLP_20 VGND sky130_fd_pr__nfet_01v8 w=0.42 l=0.17
XB57_21 VGND WL_57 BLP_21 VGND sky130_fd_pr__nfet_01v8 w=0.42 l=0.17
XB57_22 VGND WL_57 BLP_22 VGND sky130_fd_pr__nfet_01v8 w=0.42 l=0.17
XB57_23 VGND WL_57 nc_57_23 VGND sky130_fd_pr__nfet_01v8 w=0.42 l=0.17
XB57_24 VGND WL_57 nc_57_24 VGND sky130_fd_pr__nfet_01v8 w=0.42 l=0.17
XB57_25 VGND WL_57 BLN_25 VGND sky130_fd_pr__nfet_01v8 w=0.42 l=0.17
XB57_26 VGND WL_57 nc_57_26 VGND sky130_fd_pr__nfet_01v8 w=0.42 l=0.17
XB57_27 VGND WL_57 BLP_27 VGND sky130_fd_pr__nfet_01v8 w=0.42 l=0.17
XB57_28 VGND WL_57 BLP_28 VGND sky130_fd_pr__nfet_01v8 w=0.42 l=0.17
XB57_29 VGND WL_57 nc_57_29 VGND sky130_fd_pr__nfet_01v8 w=0.42 l=0.17
XB57_30 VGND WL_57 nc_57_30 VGND sky130_fd_pr__nfet_01v8 w=0.42 l=0.17
XB57_31 VGND WL_57 BLP_31 VGND sky130_fd_pr__nfet_01v8 w=0.42 l=0.17
XB58_0 VGND WL_58 nc_58_0 VGND sky130_fd_pr__nfet_01v8 w=0.42 l=0.17
XB58_1 VGND WL_58 nc_58_1 VGND sky130_fd_pr__nfet_01v8 w=0.42 l=0.17
XB58_2 VGND WL_58 nc_58_2 VGND sky130_fd_pr__nfet_01v8 w=0.42 l=0.17
XB58_3 VGND WL_58 nc_58_3 VGND sky130_fd_pr__nfet_01v8 w=0.42 l=0.17
XB58_4 VGND WL_58 BLP_4 VGND sky130_fd_pr__nfet_01v8 w=0.42 l=0.17
XB58_5 VGND WL_58 nc_58_5 VGND sky130_fd_pr__nfet_01v8 w=0.42 l=0.17
XB58_6 VGND WL_58 BLN_6 VGND sky130_fd_pr__nfet_01v8 w=0.42 l=0.17
XB58_7 VGND WL_58 nc_58_7 VGND sky130_fd_pr__nfet_01v8 w=0.42 l=0.17
XB58_8 VGND WL_58 BLN_8 VGND sky130_fd_pr__nfet_01v8 w=0.42 l=0.17
XB58_9 VGND WL_58 BLN_9 VGND sky130_fd_pr__nfet_01v8 w=0.42 l=0.17
XB58_10 VGND WL_58 nc_58_10 VGND sky130_fd_pr__nfet_01v8 w=0.42 l=0.17
XB58_11 VGND WL_58 nc_58_11 VGND sky130_fd_pr__nfet_01v8 w=0.42 l=0.17
XB58_12 VGND WL_58 nc_58_12 VGND sky130_fd_pr__nfet_01v8 w=0.42 l=0.17
XB58_13 VGND WL_58 nc_58_13 VGND sky130_fd_pr__nfet_01v8 w=0.42 l=0.17
XB58_14 VGND WL_58 BLP_14 VGND sky130_fd_pr__nfet_01v8 w=0.42 l=0.17
XB58_15 VGND WL_58 BLN_15 VGND sky130_fd_pr__nfet_01v8 w=0.42 l=0.17
XB58_16 VGND WL_58 nc_58_16 VGND sky130_fd_pr__nfet_01v8 w=0.42 l=0.17
XB58_17 VGND WL_58 nc_58_17 VGND sky130_fd_pr__nfet_01v8 w=0.42 l=0.17
XB58_18 VGND WL_58 BLP_18 VGND sky130_fd_pr__nfet_01v8 w=0.42 l=0.17
XB58_19 VGND WL_58 BLP_19 VGND sky130_fd_pr__nfet_01v8 w=0.42 l=0.17
XB58_20 VGND WL_58 nc_58_20 VGND sky130_fd_pr__nfet_01v8 w=0.42 l=0.17
XB58_21 VGND WL_58 BLN_21 VGND sky130_fd_pr__nfet_01v8 w=0.42 l=0.17
XB58_22 VGND WL_58 nc_58_22 VGND sky130_fd_pr__nfet_01v8 w=0.42 l=0.17
XB58_23 VGND WL_58 BLN_23 VGND sky130_fd_pr__nfet_01v8 w=0.42 l=0.17
XB58_24 VGND WL_58 nc_58_24 VGND sky130_fd_pr__nfet_01v8 w=0.42 l=0.17
XB58_25 VGND WL_58 BLP_25 VGND sky130_fd_pr__nfet_01v8 w=0.42 l=0.17
XB58_26 VGND WL_58 BLN_26 VGND sky130_fd_pr__nfet_01v8 w=0.42 l=0.17
XB58_27 VGND WL_58 nc_58_27 VGND sky130_fd_pr__nfet_01v8 w=0.42 l=0.17
XB58_28 VGND WL_58 BLN_28 VGND sky130_fd_pr__nfet_01v8 w=0.42 l=0.17
XB58_29 VGND WL_58 nc_58_29 VGND sky130_fd_pr__nfet_01v8 w=0.42 l=0.17
XB58_30 VGND WL_58 nc_58_30 VGND sky130_fd_pr__nfet_01v8 w=0.42 l=0.17
XB58_31 VGND WL_58 nc_58_31 VGND sky130_fd_pr__nfet_01v8 w=0.42 l=0.17
XB59_0 VGND WL_59 BLN_0 VGND sky130_fd_pr__nfet_01v8 w=0.42 l=0.17
XB59_1 VGND WL_59 nc_59_1 VGND sky130_fd_pr__nfet_01v8 w=0.42 l=0.17
XB59_2 VGND WL_59 nc_59_2 VGND sky130_fd_pr__nfet_01v8 w=0.42 l=0.17
XB59_3 VGND WL_59 BLN_3 VGND sky130_fd_pr__nfet_01v8 w=0.42 l=0.17
XB59_4 VGND WL_59 BLP_4 VGND sky130_fd_pr__nfet_01v8 w=0.42 l=0.17
XB59_5 VGND WL_59 BLN_5 VGND sky130_fd_pr__nfet_01v8 w=0.42 l=0.17
XB59_6 VGND WL_59 BLN_6 VGND sky130_fd_pr__nfet_01v8 w=0.42 l=0.17
XB59_7 VGND WL_59 BLP_7 VGND sky130_fd_pr__nfet_01v8 w=0.42 l=0.17
XB59_8 VGND WL_59 BLP_8 VGND sky130_fd_pr__nfet_01v8 w=0.42 l=0.17
XB59_9 VGND WL_59 nc_59_9 VGND sky130_fd_pr__nfet_01v8 w=0.42 l=0.17
XB59_10 VGND WL_59 BLP_10 VGND sky130_fd_pr__nfet_01v8 w=0.42 l=0.17
XB59_11 VGND WL_59 nc_59_11 VGND sky130_fd_pr__nfet_01v8 w=0.42 l=0.17
XB59_12 VGND WL_59 BLN_12 VGND sky130_fd_pr__nfet_01v8 w=0.42 l=0.17
XB59_13 VGND WL_59 nc_59_13 VGND sky130_fd_pr__nfet_01v8 w=0.42 l=0.17
XB59_14 VGND WL_59 BLN_14 VGND sky130_fd_pr__nfet_01v8 w=0.42 l=0.17
XB59_15 VGND WL_59 nc_59_15 VGND sky130_fd_pr__nfet_01v8 w=0.42 l=0.17
XB59_16 VGND WL_59 nc_59_16 VGND sky130_fd_pr__nfet_01v8 w=0.42 l=0.17
XB59_17 VGND WL_59 nc_59_17 VGND sky130_fd_pr__nfet_01v8 w=0.42 l=0.17
XB59_18 VGND WL_59 nc_59_18 VGND sky130_fd_pr__nfet_01v8 w=0.42 l=0.17
XB59_19 VGND WL_59 BLP_19 VGND sky130_fd_pr__nfet_01v8 w=0.42 l=0.17
XB59_20 VGND WL_59 BLN_20 VGND sky130_fd_pr__nfet_01v8 w=0.42 l=0.17
XB59_21 VGND WL_59 nc_59_21 VGND sky130_fd_pr__nfet_01v8 w=0.42 l=0.17
XB59_22 VGND WL_59 BLN_22 VGND sky130_fd_pr__nfet_01v8 w=0.42 l=0.17
XB59_23 VGND WL_59 BLP_23 VGND sky130_fd_pr__nfet_01v8 w=0.42 l=0.17
XB59_24 VGND WL_59 nc_59_24 VGND sky130_fd_pr__nfet_01v8 w=0.42 l=0.17
XB59_25 VGND WL_59 nc_59_25 VGND sky130_fd_pr__nfet_01v8 w=0.42 l=0.17
XB59_26 VGND WL_59 BLP_26 VGND sky130_fd_pr__nfet_01v8 w=0.42 l=0.17
XB59_27 VGND WL_59 BLN_27 VGND sky130_fd_pr__nfet_01v8 w=0.42 l=0.17
XB59_28 VGND WL_59 nc_59_28 VGND sky130_fd_pr__nfet_01v8 w=0.42 l=0.17
XB59_29 VGND WL_59 nc_59_29 VGND sky130_fd_pr__nfet_01v8 w=0.42 l=0.17
XB59_30 VGND WL_59 nc_59_30 VGND sky130_fd_pr__nfet_01v8 w=0.42 l=0.17
XB59_31 VGND WL_59 nc_59_31 VGND sky130_fd_pr__nfet_01v8 w=0.42 l=0.17
XB60_0 VGND WL_60 nc_60_0 VGND sky130_fd_pr__nfet_01v8 w=0.42 l=0.17
XB60_1 VGND WL_60 BLN_1 VGND sky130_fd_pr__nfet_01v8 w=0.42 l=0.17
XB60_2 VGND WL_60 BLP_2 VGND sky130_fd_pr__nfet_01v8 w=0.42 l=0.17
XB60_3 VGND WL_60 nc_60_3 VGND sky130_fd_pr__nfet_01v8 w=0.42 l=0.17
XB60_4 VGND WL_60 BLN_4 VGND sky130_fd_pr__nfet_01v8 w=0.42 l=0.17
XB60_5 VGND WL_60 nc_60_5 VGND sky130_fd_pr__nfet_01v8 w=0.42 l=0.17
XB60_6 VGND WL_60 nc_60_6 VGND sky130_fd_pr__nfet_01v8 w=0.42 l=0.17
XB60_7 VGND WL_60 nc_60_7 VGND sky130_fd_pr__nfet_01v8 w=0.42 l=0.17
XB60_8 VGND WL_60 BLN_8 VGND sky130_fd_pr__nfet_01v8 w=0.42 l=0.17
XB60_9 VGND WL_60 BLP_9 VGND sky130_fd_pr__nfet_01v8 w=0.42 l=0.17
XB60_10 VGND WL_60 nc_60_10 VGND sky130_fd_pr__nfet_01v8 w=0.42 l=0.17
XB60_11 VGND WL_60 nc_60_11 VGND sky130_fd_pr__nfet_01v8 w=0.42 l=0.17
XB60_12 VGND WL_60 BLP_12 VGND sky130_fd_pr__nfet_01v8 w=0.42 l=0.17
XB60_13 VGND WL_60 nc_60_13 VGND sky130_fd_pr__nfet_01v8 w=0.42 l=0.17
XB60_14 VGND WL_60 BLP_14 VGND sky130_fd_pr__nfet_01v8 w=0.42 l=0.17
XB60_15 VGND WL_60 BLP_15 VGND sky130_fd_pr__nfet_01v8 w=0.42 l=0.17
XB60_16 VGND WL_60 nc_60_16 VGND sky130_fd_pr__nfet_01v8 w=0.42 l=0.17
XB60_17 VGND WL_60 BLP_17 VGND sky130_fd_pr__nfet_01v8 w=0.42 l=0.17
XB60_18 VGND WL_60 BLP_18 VGND sky130_fd_pr__nfet_01v8 w=0.42 l=0.17
XB60_19 VGND WL_60 nc_60_19 VGND sky130_fd_pr__nfet_01v8 w=0.42 l=0.17
XB60_20 VGND WL_60 nc_60_20 VGND sky130_fd_pr__nfet_01v8 w=0.42 l=0.17
XB60_21 VGND WL_60 nc_60_21 VGND sky130_fd_pr__nfet_01v8 w=0.42 l=0.17
XB60_22 VGND WL_60 BLN_22 VGND sky130_fd_pr__nfet_01v8 w=0.42 l=0.17
XB60_23 VGND WL_60 BLN_23 VGND sky130_fd_pr__nfet_01v8 w=0.42 l=0.17
XB60_24 VGND WL_60 nc_60_24 VGND sky130_fd_pr__nfet_01v8 w=0.42 l=0.17
XB60_25 VGND WL_60 nc_60_25 VGND sky130_fd_pr__nfet_01v8 w=0.42 l=0.17
XB60_26 VGND WL_60 BLN_26 VGND sky130_fd_pr__nfet_01v8 w=0.42 l=0.17
XB60_27 VGND WL_60 nc_60_27 VGND sky130_fd_pr__nfet_01v8 w=0.42 l=0.17
XB60_28 VGND WL_60 BLN_28 VGND sky130_fd_pr__nfet_01v8 w=0.42 l=0.17
XB60_29 VGND WL_60 BLN_29 VGND sky130_fd_pr__nfet_01v8 w=0.42 l=0.17
XB60_30 VGND WL_60 nc_60_30 VGND sky130_fd_pr__nfet_01v8 w=0.42 l=0.17
XB60_31 VGND WL_60 BLP_31 VGND sky130_fd_pr__nfet_01v8 w=0.42 l=0.17
XB61_0 VGND WL_61 BLN_0 VGND sky130_fd_pr__nfet_01v8 w=0.42 l=0.17
XB61_1 VGND WL_61 BLP_1 VGND sky130_fd_pr__nfet_01v8 w=0.42 l=0.17
XB61_2 VGND WL_61 nc_61_2 VGND sky130_fd_pr__nfet_01v8 w=0.42 l=0.17
XB61_3 VGND WL_61 nc_61_3 VGND sky130_fd_pr__nfet_01v8 w=0.42 l=0.17
XB61_4 VGND WL_61 BLP_4 VGND sky130_fd_pr__nfet_01v8 w=0.42 l=0.17
XB61_5 VGND WL_61 BLP_5 VGND sky130_fd_pr__nfet_01v8 w=0.42 l=0.17
XB61_6 VGND WL_61 nc_61_6 VGND sky130_fd_pr__nfet_01v8 w=0.42 l=0.17
XB61_7 VGND WL_61 nc_61_7 VGND sky130_fd_pr__nfet_01v8 w=0.42 l=0.17
XB61_8 VGND WL_61 BLN_8 VGND sky130_fd_pr__nfet_01v8 w=0.42 l=0.17
XB61_9 VGND WL_61 nc_61_9 VGND sky130_fd_pr__nfet_01v8 w=0.42 l=0.17
XB61_10 VGND WL_61 nc_61_10 VGND sky130_fd_pr__nfet_01v8 w=0.42 l=0.17
XB61_11 VGND WL_61 BLN_11 VGND sky130_fd_pr__nfet_01v8 w=0.42 l=0.17
XB61_12 VGND WL_61 nc_61_12 VGND sky130_fd_pr__nfet_01v8 w=0.42 l=0.17
XB61_13 VGND WL_61 BLP_13 VGND sky130_fd_pr__nfet_01v8 w=0.42 l=0.17
XB61_14 VGND WL_61 BLP_14 VGND sky130_fd_pr__nfet_01v8 w=0.42 l=0.17
XB61_15 VGND WL_61 BLP_15 VGND sky130_fd_pr__nfet_01v8 w=0.42 l=0.17
XB61_16 VGND WL_61 nc_61_16 VGND sky130_fd_pr__nfet_01v8 w=0.42 l=0.17
XB61_17 VGND WL_61 BLN_17 VGND sky130_fd_pr__nfet_01v8 w=0.42 l=0.17
XB61_18 VGND WL_61 BLP_18 VGND sky130_fd_pr__nfet_01v8 w=0.42 l=0.17
XB61_19 VGND WL_61 nc_61_19 VGND sky130_fd_pr__nfet_01v8 w=0.42 l=0.17
XB61_20 VGND WL_61 BLN_20 VGND sky130_fd_pr__nfet_01v8 w=0.42 l=0.17
XB61_21 VGND WL_61 BLP_21 VGND sky130_fd_pr__nfet_01v8 w=0.42 l=0.17
XB61_22 VGND WL_61 BLN_22 VGND sky130_fd_pr__nfet_01v8 w=0.42 l=0.17
XB61_23 VGND WL_61 nc_61_23 VGND sky130_fd_pr__nfet_01v8 w=0.42 l=0.17
XB61_24 VGND WL_61 BLN_24 VGND sky130_fd_pr__nfet_01v8 w=0.42 l=0.17
XB61_25 VGND WL_61 BLN_25 VGND sky130_fd_pr__nfet_01v8 w=0.42 l=0.17
XB61_26 VGND WL_61 BLP_26 VGND sky130_fd_pr__nfet_01v8 w=0.42 l=0.17
XB61_27 VGND WL_61 BLP_27 VGND sky130_fd_pr__nfet_01v8 w=0.42 l=0.17
XB61_28 VGND WL_61 BLP_28 VGND sky130_fd_pr__nfet_01v8 w=0.42 l=0.17
XB61_29 VGND WL_61 BLP_29 VGND sky130_fd_pr__nfet_01v8 w=0.42 l=0.17
XB61_30 VGND WL_61 nc_61_30 VGND sky130_fd_pr__nfet_01v8 w=0.42 l=0.17
XB61_31 VGND WL_61 nc_61_31 VGND sky130_fd_pr__nfet_01v8 w=0.42 l=0.17
XB62_0 VGND WL_62 nc_62_0 VGND sky130_fd_pr__nfet_01v8 w=0.42 l=0.17
XB62_1 VGND WL_62 nc_62_1 VGND sky130_fd_pr__nfet_01v8 w=0.42 l=0.17
XB62_2 VGND WL_62 BLN_2 VGND sky130_fd_pr__nfet_01v8 w=0.42 l=0.17
XB62_3 VGND WL_62 nc_62_3 VGND sky130_fd_pr__nfet_01v8 w=0.42 l=0.17
XB62_4 VGND WL_62 nc_62_4 VGND sky130_fd_pr__nfet_01v8 w=0.42 l=0.17
XB62_5 VGND WL_62 nc_62_5 VGND sky130_fd_pr__nfet_01v8 w=0.42 l=0.17
XB62_6 VGND WL_62 BLN_6 VGND sky130_fd_pr__nfet_01v8 w=0.42 l=0.17
XB62_7 VGND WL_62 nc_62_7 VGND sky130_fd_pr__nfet_01v8 w=0.42 l=0.17
XB62_8 VGND WL_62 nc_62_8 VGND sky130_fd_pr__nfet_01v8 w=0.42 l=0.17
XB62_9 VGND WL_62 BLP_9 VGND sky130_fd_pr__nfet_01v8 w=0.42 l=0.17
XB62_10 VGND WL_62 nc_62_10 VGND sky130_fd_pr__nfet_01v8 w=0.42 l=0.17
XB62_11 VGND WL_62 nc_62_11 VGND sky130_fd_pr__nfet_01v8 w=0.42 l=0.17
XB62_12 VGND WL_62 nc_62_12 VGND sky130_fd_pr__nfet_01v8 w=0.42 l=0.17
XB62_13 VGND WL_62 nc_62_13 VGND sky130_fd_pr__nfet_01v8 w=0.42 l=0.17
XB62_14 VGND WL_62 BLP_14 VGND sky130_fd_pr__nfet_01v8 w=0.42 l=0.17
XB62_15 VGND WL_62 nc_62_15 VGND sky130_fd_pr__nfet_01v8 w=0.42 l=0.17
XB62_16 VGND WL_62 BLN_16 VGND sky130_fd_pr__nfet_01v8 w=0.42 l=0.17
XB62_17 VGND WL_62 BLN_17 VGND sky130_fd_pr__nfet_01v8 w=0.42 l=0.17
XB62_18 VGND WL_62 nc_62_18 VGND sky130_fd_pr__nfet_01v8 w=0.42 l=0.17
XB62_19 VGND WL_62 BLN_19 VGND sky130_fd_pr__nfet_01v8 w=0.42 l=0.17
XB62_20 VGND WL_62 nc_62_20 VGND sky130_fd_pr__nfet_01v8 w=0.42 l=0.17
XB62_21 VGND WL_62 nc_62_21 VGND sky130_fd_pr__nfet_01v8 w=0.42 l=0.17
XB62_22 VGND WL_62 BLP_22 VGND sky130_fd_pr__nfet_01v8 w=0.42 l=0.17
XB62_23 VGND WL_62 BLN_23 VGND sky130_fd_pr__nfet_01v8 w=0.42 l=0.17
XB62_24 VGND WL_62 BLN_24 VGND sky130_fd_pr__nfet_01v8 w=0.42 l=0.17
XB62_25 VGND WL_62 BLP_25 VGND sky130_fd_pr__nfet_01v8 w=0.42 l=0.17
XB62_26 VGND WL_62 BLN_26 VGND sky130_fd_pr__nfet_01v8 w=0.42 l=0.17
XB62_27 VGND WL_62 nc_62_27 VGND sky130_fd_pr__nfet_01v8 w=0.42 l=0.17
XB62_28 VGND WL_62 nc_62_28 VGND sky130_fd_pr__nfet_01v8 w=0.42 l=0.17
XB62_29 VGND WL_62 nc_62_29 VGND sky130_fd_pr__nfet_01v8 w=0.42 l=0.17
XB62_30 VGND WL_62 BLP_30 VGND sky130_fd_pr__nfet_01v8 w=0.42 l=0.17
XB62_31 VGND WL_62 BLP_31 VGND sky130_fd_pr__nfet_01v8 w=0.42 l=0.17
XB63_0 VGND WL_63 BLP_0 VGND sky130_fd_pr__nfet_01v8 w=0.42 l=0.17
XB63_1 VGND WL_63 BLN_1 VGND sky130_fd_pr__nfet_01v8 w=0.42 l=0.17
XB63_2 VGND WL_63 BLP_2 VGND sky130_fd_pr__nfet_01v8 w=0.42 l=0.17
XB63_3 VGND WL_63 nc_63_3 VGND sky130_fd_pr__nfet_01v8 w=0.42 l=0.17
XB63_4 VGND WL_63 BLP_4 VGND sky130_fd_pr__nfet_01v8 w=0.42 l=0.17
XB63_5 VGND WL_63 nc_63_5 VGND sky130_fd_pr__nfet_01v8 w=0.42 l=0.17
XB63_6 VGND WL_63 nc_63_6 VGND sky130_fd_pr__nfet_01v8 w=0.42 l=0.17
XB63_7 VGND WL_63 nc_63_7 VGND sky130_fd_pr__nfet_01v8 w=0.42 l=0.17
XB63_8 VGND WL_63 BLN_8 VGND sky130_fd_pr__nfet_01v8 w=0.42 l=0.17
XB63_9 VGND WL_63 BLP_9 VGND sky130_fd_pr__nfet_01v8 w=0.42 l=0.17
XB63_10 VGND WL_63 nc_63_10 VGND sky130_fd_pr__nfet_01v8 w=0.42 l=0.17
XB63_11 VGND WL_63 nc_63_11 VGND sky130_fd_pr__nfet_01v8 w=0.42 l=0.17
XB63_12 VGND WL_63 nc_63_12 VGND sky130_fd_pr__nfet_01v8 w=0.42 l=0.17
XB63_13 VGND WL_63 nc_63_13 VGND sky130_fd_pr__nfet_01v8 w=0.42 l=0.17
XB63_14 VGND WL_63 nc_63_14 VGND sky130_fd_pr__nfet_01v8 w=0.42 l=0.17
XB63_15 VGND WL_63 BLN_15 VGND sky130_fd_pr__nfet_01v8 w=0.42 l=0.17
XB63_16 VGND WL_63 BLN_16 VGND sky130_fd_pr__nfet_01v8 w=0.42 l=0.17
XB63_17 VGND WL_63 BLN_17 VGND sky130_fd_pr__nfet_01v8 w=0.42 l=0.17
XB63_18 VGND WL_63 BLN_18 VGND sky130_fd_pr__nfet_01v8 w=0.42 l=0.17
XB63_19 VGND WL_63 BLP_19 VGND sky130_fd_pr__nfet_01v8 w=0.42 l=0.17
XB63_20 VGND WL_63 BLP_20 VGND sky130_fd_pr__nfet_01v8 w=0.42 l=0.17
XB63_21 VGND WL_63 BLN_21 VGND sky130_fd_pr__nfet_01v8 w=0.42 l=0.17
XB63_22 VGND WL_63 nc_63_22 VGND sky130_fd_pr__nfet_01v8 w=0.42 l=0.17
XB63_23 VGND WL_63 nc_63_23 VGND sky130_fd_pr__nfet_01v8 w=0.42 l=0.17
XB63_24 VGND WL_63 BLP_24 VGND sky130_fd_pr__nfet_01v8 w=0.42 l=0.17
XB63_25 VGND WL_63 nc_63_25 VGND sky130_fd_pr__nfet_01v8 w=0.42 l=0.17
XB63_26 VGND WL_63 BLN_26 VGND sky130_fd_pr__nfet_01v8 w=0.42 l=0.17
XB63_27 VGND WL_63 BLN_27 VGND sky130_fd_pr__nfet_01v8 w=0.42 l=0.17
XB63_28 VGND WL_63 nc_63_28 VGND sky130_fd_pr__nfet_01v8 w=0.42 l=0.17
XB63_29 VGND WL_63 nc_63_29 VGND sky130_fd_pr__nfet_01v8 w=0.42 l=0.17
XB63_30 VGND WL_63 BLN_30 VGND sky130_fd_pr__nfet_01v8 w=0.42 l=0.17
XB63_31 VGND WL_63 nc_63_31 VGND sky130_fd_pr__nfet_01v8 w=0.42 l=0.17
XPP0 VPWR PRE_N BLP_0 VPWR sky130_fd_pr__pfet_01v8 w=1.0 l=0.15
XPN0 VPWR PRE_N BLN_0 VPWR sky130_fd_pr__pfet_01v8 w=1.0 l=0.15
XPP1 VPWR PRE_N BLP_1 VPWR sky130_fd_pr__pfet_01v8 w=1.0 l=0.15
XPN1 VPWR PRE_N BLN_1 VPWR sky130_fd_pr__pfet_01v8 w=1.0 l=0.15
XPP2 VPWR PRE_N BLP_2 VPWR sky130_fd_pr__pfet_01v8 w=1.0 l=0.15
XPN2 VPWR PRE_N BLN_2 VPWR sky130_fd_pr__pfet_01v8 w=1.0 l=0.15
XPP3 VPWR PRE_N BLP_3 VPWR sky130_fd_pr__pfet_01v8 w=1.0 l=0.15
XPN3 VPWR PRE_N BLN_3 VPWR sky130_fd_pr__pfet_01v8 w=1.0 l=0.15
XPP4 VPWR PRE_N BLP_4 VPWR sky130_fd_pr__pfet_01v8 w=1.0 l=0.15
XPN4 VPWR PRE_N BLN_4 VPWR sky130_fd_pr__pfet_01v8 w=1.0 l=0.15
XPP5 VPWR PRE_N BLP_5 VPWR sky130_fd_pr__pfet_01v8 w=1.0 l=0.15
XPN5 VPWR PRE_N BLN_5 VPWR sky130_fd_pr__pfet_01v8 w=1.0 l=0.15
XPP6 VPWR PRE_N BLP_6 VPWR sky130_fd_pr__pfet_01v8 w=1.0 l=0.15
XPN6 VPWR PRE_N BLN_6 VPWR sky130_fd_pr__pfet_01v8 w=1.0 l=0.15
XPP7 VPWR PRE_N BLP_7 VPWR sky130_fd_pr__pfet_01v8 w=1.0 l=0.15
XPN7 VPWR PRE_N BLN_7 VPWR sky130_fd_pr__pfet_01v8 w=1.0 l=0.15
XPP8 VPWR PRE_N BLP_8 VPWR sky130_fd_pr__pfet_01v8 w=1.0 l=0.15
XPN8 VPWR PRE_N BLN_8 VPWR sky130_fd_pr__pfet_01v8 w=1.0 l=0.15
XPP9 VPWR PRE_N BLP_9 VPWR sky130_fd_pr__pfet_01v8 w=1.0 l=0.15
XPN9 VPWR PRE_N BLN_9 VPWR sky130_fd_pr__pfet_01v8 w=1.0 l=0.15
XPP10 VPWR PRE_N BLP_10 VPWR sky130_fd_pr__pfet_01v8 w=1.0 l=0.15
XPN10 VPWR PRE_N BLN_10 VPWR sky130_fd_pr__pfet_01v8 w=1.0 l=0.15
XPP11 VPWR PRE_N BLP_11 VPWR sky130_fd_pr__pfet_01v8 w=1.0 l=0.15
XPN11 VPWR PRE_N BLN_11 VPWR sky130_fd_pr__pfet_01v8 w=1.0 l=0.15
XPP12 VPWR PRE_N BLP_12 VPWR sky130_fd_pr__pfet_01v8 w=1.0 l=0.15
XPN12 VPWR PRE_N BLN_12 VPWR sky130_fd_pr__pfet_01v8 w=1.0 l=0.15
XPP13 VPWR PRE_N BLP_13 VPWR sky130_fd_pr__pfet_01v8 w=1.0 l=0.15
XPN13 VPWR PRE_N BLN_13 VPWR sky130_fd_pr__pfet_01v8 w=1.0 l=0.15
XPP14 VPWR PRE_N BLP_14 VPWR sky130_fd_pr__pfet_01v8 w=1.0 l=0.15
XPN14 VPWR PRE_N BLN_14 VPWR sky130_fd_pr__pfet_01v8 w=1.0 l=0.15
XPP15 VPWR PRE_N BLP_15 VPWR sky130_fd_pr__pfet_01v8 w=1.0 l=0.15
XPN15 VPWR PRE_N BLN_15 VPWR sky130_fd_pr__pfet_01v8 w=1.0 l=0.15
XPP16 VPWR PRE_N BLP_16 VPWR sky130_fd_pr__pfet_01v8 w=1.0 l=0.15
XPN16 VPWR PRE_N BLN_16 VPWR sky130_fd_pr__pfet_01v8 w=1.0 l=0.15
XPP17 VPWR PRE_N BLP_17 VPWR sky130_fd_pr__pfet_01v8 w=1.0 l=0.15
XPN17 VPWR PRE_N BLN_17 VPWR sky130_fd_pr__pfet_01v8 w=1.0 l=0.15
XPP18 VPWR PRE_N BLP_18 VPWR sky130_fd_pr__pfet_01v8 w=1.0 l=0.15
XPN18 VPWR PRE_N BLN_18 VPWR sky130_fd_pr__pfet_01v8 w=1.0 l=0.15
XPP19 VPWR PRE_N BLP_19 VPWR sky130_fd_pr__pfet_01v8 w=1.0 l=0.15
XPN19 VPWR PRE_N BLN_19 VPWR sky130_fd_pr__pfet_01v8 w=1.0 l=0.15
XPP20 VPWR PRE_N BLP_20 VPWR sky130_fd_pr__pfet_01v8 w=1.0 l=0.15
XPN20 VPWR PRE_N BLN_20 VPWR sky130_fd_pr__pfet_01v8 w=1.0 l=0.15
XPP21 VPWR PRE_N BLP_21 VPWR sky130_fd_pr__pfet_01v8 w=1.0 l=0.15
XPN21 VPWR PRE_N BLN_21 VPWR sky130_fd_pr__pfet_01v8 w=1.0 l=0.15
XPP22 VPWR PRE_N BLP_22 VPWR sky130_fd_pr__pfet_01v8 w=1.0 l=0.15
XPN22 VPWR PRE_N BLN_22 VPWR sky130_fd_pr__pfet_01v8 w=1.0 l=0.15
XPP23 VPWR PRE_N BLP_23 VPWR sky130_fd_pr__pfet_01v8 w=1.0 l=0.15
XPN23 VPWR PRE_N BLN_23 VPWR sky130_fd_pr__pfet_01v8 w=1.0 l=0.15
XPP24 VPWR PRE_N BLP_24 VPWR sky130_fd_pr__pfet_01v8 w=1.0 l=0.15
XPN24 VPWR PRE_N BLN_24 VPWR sky130_fd_pr__pfet_01v8 w=1.0 l=0.15
XPP25 VPWR PRE_N BLP_25 VPWR sky130_fd_pr__pfet_01v8 w=1.0 l=0.15
XPN25 VPWR PRE_N BLN_25 VPWR sky130_fd_pr__pfet_01v8 w=1.0 l=0.15
XPP26 VPWR PRE_N BLP_26 VPWR sky130_fd_pr__pfet_01v8 w=1.0 l=0.15
XPN26 VPWR PRE_N BLN_26 VPWR sky130_fd_pr__pfet_01v8 w=1.0 l=0.15
XPP27 VPWR PRE_N BLP_27 VPWR sky130_fd_pr__pfet_01v8 w=1.0 l=0.15
XPN27 VPWR PRE_N BLN_27 VPWR sky130_fd_pr__pfet_01v8 w=1.0 l=0.15
XPP28 VPWR PRE_N BLP_28 VPWR sky130_fd_pr__pfet_01v8 w=1.0 l=0.15
XPN28 VPWR PRE_N BLN_28 VPWR sky130_fd_pr__pfet_01v8 w=1.0 l=0.15
XPP29 VPWR PRE_N BLP_29 VPWR sky130_fd_pr__pfet_01v8 w=1.0 l=0.15
XPN29 VPWR PRE_N BLN_29 VPWR sky130_fd_pr__pfet_01v8 w=1.0 l=0.15
XPP30 VPWR PRE_N BLP_30 VPWR sky130_fd_pr__pfet_01v8 w=1.0 l=0.15
XPN30 VPWR PRE_N BLN_30 VPWR sky130_fd_pr__pfet_01v8 w=1.0 l=0.15
XPP31 VPWR PRE_N BLP_31 VPWR sky130_fd_pr__pfet_01v8 w=1.0 l=0.15
XPN31 VPWR PRE_N BLN_31 VPWR sky130_fd_pr__pfet_01v8 w=1.0 l=0.15
.ends macro_array_pc_64x32_test0
